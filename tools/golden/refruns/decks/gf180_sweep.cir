* SPDX-License-Identifier: Apache-2.0
* Copyright 2026 The Hefesto Authors
* Hefesto-authored reference deck (openspec/changes/m9-lvs-simulation task 3.3; D-27).
* gf180mcu typical: 3.3 V nfet and pfet with two fingers (nf, the parameter the ngspice
* compatibility modes treat differently), swept in Vgs. Run once with ngbehavior=hs and once
* with hsa; the run compares the mean drain currents.
.include "@GF180@/gf180mcuD/libs.tech/ngspice/design.ngspice"
.lib "@GF180@/gf180mcuD/libs.tech/ngspice/sm141064.ngspice" typical
Vdd d 0 3.3
Vgn gn 0 0
Vmn d dn 0
XN dn gn 0 0 nfet_03v3 w=2u l=0.28u nf=2
Vss s 0 3.3
Vgp gp 0 3.3
Vmp s sp 0
XP 0 gp sp s pfet_03v3 w=2u l=0.28u nf=2
.control
set numdgt=12
dc Vgn 0 3.3 0.33
let inm = mean(abs(i(Vmn)))
echo "HREF in=$&inm"
dc Vgp 3.3 0 -0.33
let ipm = mean(abs(i(Vmp)))
echo "HREF ip=$&ipm"
.endc
.end

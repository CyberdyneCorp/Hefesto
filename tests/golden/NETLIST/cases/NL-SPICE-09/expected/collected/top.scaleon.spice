* SPICE3 file created from top.ext - technology: nltest

.option scale=10n

M1000 x g a GND nfet w=8 l=2
+  ad=30p pd=16u as=40p ps=26u
M1001 b g a GND nfet w=8 l=2
+  ad=40p pd=26u as=12p ps=14u
M1002 x g b GND nfet w=8 l=2
+  ad=0 pd=0 as=0 ps=0
Mext:aps b g a GND nfet w=8 l=2
+  ad=0 pd=0 as=0 ps=0 * asub=0 psub=0
**devattr g=ext:aps

* SPICE3 file created from top.ext - technology: nltest

.option scale=10n

M1000 d g s GND nfet w=4 l=2
+  ad=0 pd=0 as=0 ps=0
X0 GND k4 dmod
M1001 d g s GND nfet w=4 l=4
+  ad=0 pd=0 as=0 ps=0
C0 cb ct3 mimcapm w=10 l=10
Q1002 GND b e npn
M1003 d2 g s GND nfet w=4 l=2
+  ad=0 pd=0 as=0 ps=0
C1 ct2 cb mimcapm w=10 l=10
D0 GND k3 ndn
R0 ra rc rppd w=2 l=10
X1 ra3 rc3 rres
D1 k GND dn
X2 ct4 cb cmod
X3 x1 x2 sbx
R1 ra rc 25.500000
N4 va1 va2 vamod
X5 d g s GND nmod w=4 l=2
D2 k2 GND pdn
C2 ct cb 12.5f

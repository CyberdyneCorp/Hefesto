* SPICE3 file created from top.ext - technology: nltest

.option scale=10n

Mu1foo u1/b u1/g x GND nfet w=4 l=2
+  ad=0 pd=0 as=0 ps=0
**devattr g=foo
** SOURCE/DRAIN TIED
M1000 x u1/g x GND nfet w=4 l=2
+  ad=0 pd=0 as=0 ps=0
M1001 x u1/g u1/b GND nfet w=4 l=2
+  ad=0 pd=0 as=0 ps=0
**devattr d=D

* SPICE3 file created from top.ext - technology: nltest

.option scale=10n

M1000 u:1|a.b/e[1] u:1|a.b/a|b u:1|a.b/c:d GND nfet w=4 l=2
+  ad=0 pd=0 as=0 ps=0
M1001 u:1|a.b/i u:1|a.b/f.g u:1|a.b/h# GND nfet w=4 l=2
+  ad=0 pd=0 as=0 ps=0
M1002 t.o|p t.o|p t.o|p GND nfet w=4 l=2
+  ad=0 pd=0 as=0 ps=0

* HSPICE file created from top.ext - technology: nltest

.option scale=10n

M1000 x0/e[1] x0/a|b x0/c:d GND nfet w=4 l=2
+  ad=0 pd=0 as=0 ps=0
M1001 x0/i x0/f@g x0/h GND nfet w=4 l=2
+  ad=0 pd=0 as=0 ps=0
M1002 t@o|p t@o|p t@o|p GND nfet w=4 l=2
+  ad=0 pd=0 as=0 ps=0

** hspice subcircuit dictionary
* x0	u:1|a.b

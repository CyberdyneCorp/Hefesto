* HSPICE file created from top.ext - technology: nltest

.option scale=10n

.global VDD GND

.subckt leaf3 z@10
M1000 b b z@10 GND nfet w=4 l=2
+  ad=0 pd=0 as=0 ps=0
.ends

.subckt mid
Xaverylonginstancename z@10 leaf3
.ends

.subckt top
Xm1 mid
M1000 z@10 t t GND nfet w=4 l=2
+  ad=0 pd=0 as=0 ps=0
.ends

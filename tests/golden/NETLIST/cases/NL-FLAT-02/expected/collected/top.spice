* SPICE3 file created from top.ext - technology: nltest

.option scale=10n

M1000 c1/x c1/x c1/y GND nfet w=6 l=3
+  ad=0 pd=0 as=0 ps=0
M1001 c1/y p p GND nfet w=4 l=2
+  ad=0 pd=0 as=0 ps=0

* SPICE3 file created from topp.ext - technology: nltest

.option scale=10n

.global VDD GND

.subckt topp in out
M1000 out in gnd gnd nfet w=4 l=2
+  ad=40p pd=26u as=20p ps=18u
M1001 out in vdd vdd pfet w=8 l=2
+  ad=0 pd=0 as=40p ps=26u
.ends

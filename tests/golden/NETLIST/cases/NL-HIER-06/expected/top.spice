* SPICE3 file created from top.ext - technology: nltest

.option scale=10n

.global VDD GND

.subckt rcell A B
R0A m A rppd w=3 l=5
R0B m B rppd w=3 l=5
X0A A m rres
X0B m B rres
V0 A B 0.0
C0 m A -1f
C1 A VSUB 3f
C2 B VSUB 3f
C3 m VSUB 2f
.ends

* Top level circuit top

Xc1 n c1/B rcell
Xc2 n c2/B rcell
C0 n c2/VSUB 1f
.end

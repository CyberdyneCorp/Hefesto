* SPICE2 file created from inv.ext - technology: nltest

.option scale=10n

M1000 10 11 12 gnd nfet w=4 l=2
+  ad=40p pd=26u as=20p ps=18u
M1001 10 11 13 vdd pfet w=8 l=2
+  ad=0 pd=0 as=40p ps=26u
** in == 11
** out == 10
C0 10 0 5f
** vdd == 13
** gnd == 12

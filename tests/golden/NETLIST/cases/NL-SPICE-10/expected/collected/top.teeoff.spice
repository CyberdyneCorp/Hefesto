* SPICE3 file created from top.ext - technology: nltest

.option scale=10n

R0 ra rc rppd w=2 l=10
X0 ra rc sub1 rres
R1 ra rc 25.500000
X1 ra rc rres
C0 ra 0 3f **FLOATING
C1 rc 0 3f **FLOATING
C2 sub1 0 1f **FLOATING

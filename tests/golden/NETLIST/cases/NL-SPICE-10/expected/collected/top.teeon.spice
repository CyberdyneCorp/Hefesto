* SPICE3 file created from top.ext - technology: nltest

.option scale=10n

R0A rb ra rppd w=2 l=5
R0B rb rc rppd w=2 l=5
X0A ra rb sub1 rres
R1A rb ra 12.750000
R1B rb rc 12.750000
X1A ra rb rres
C0 rb 0 4f **FLOATING
C1 ra 0 1f **FLOATING
C2 rc 0 1f **FLOATING
C3 sub1 0 1f **FLOATING

* SPICE3 file created from top.ext - technology: extsmoke

.option scale=10n

* SPICE3 file created from top.ext - technology: nltest

.option scale=10n

M1000 u[1|1]/in a u[1|1]/in GND nfet w=4 l=2
+  ad=0 pd=0 as=0 ps=0
M1001 u[2|1]/in u[1|0]/in u[2|1]/in GND nfet w=4 l=2
+  ad=0 pd=0 as=0 ps=0
M1002 u[2|0]/out u[2|0]/in u[2|0]/out GND nfet w=4 l=2
+  ad=0 pd=0 as=0 ps=0
M1003 u[0|1]/out u[0|1]/in u[0|1]/out GND nfet w=4 l=2
+  ad=0 pd=0 as=0 ps=0
M1004 u[1|1]/out u[1|1]/in u[1|1]/out GND nfet w=4 l=2
+  ad=0 pd=0 as=0 ps=0
M1005 u[2|1]/out u[2|1]/in u[2|1]/out GND nfet w=4 l=2
+  ad=0 pd=0 as=0 ps=0
M1006 a a b GND nfet w=4 l=2
+  ad=0 pd=0 as=0 ps=0
C0 u[1|1]/in a 2.5f
R0 a b 100.001
C1 b 0 1f **FLOATING
C2 u[2|1]/out 0 1f
C3 u[1|1]/out 0 1f
C4 u[0|1]/in 0 1f
C5 u[0|1]/out 0 1f
C6 u[2|0]/in 0 1f
C7 u[2|0]/out 0 1f
C8 u[1|0]/in 0 1f
C9 u[2|1]/in 0 2f
C10 a 0 2f
**nodeattr a : cap=10f
C11 u[1|1]/in 0 2f

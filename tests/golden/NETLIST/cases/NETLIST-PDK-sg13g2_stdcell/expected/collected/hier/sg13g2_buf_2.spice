* NGSPICE file created from sg13g2_buf_2.ext - technology: ihp-sg13g2

.subckt sg13g2_buf_2 VSS VDD X A
X0 a_41_304# A VSS VSS sg13_lv_nmos ad=0.2176p pd=1.96u as=0.1371p ps=1.12u w=0.64u l=0.13u
X1 a_41_304# A VDD VDD sg13_lv_pmos ad=0.34p pd=2.68u as=0.2086p ps=1.5u w=1u l=0.13u
X2 X a_41_304# VSS VSS sg13_lv_nmos ad=0.1406p pd=1.12u as=0.2516p ps=2.16u w=0.74u l=0.13u
X3 X a_41_304# VDD VDD sg13_lv_pmos ad=0.2128p pd=1.5u as=0.7336p ps=3.55u w=1.12u l=0.13u
X4 VSS a_41_304# X VSS sg13_lv_nmos ad=0.1371p pd=1.12u as=0.1406p ps=1.12u w=0.74u l=0.13u
X5 VDD a_41_304# X VDD sg13_lv_pmos ad=0.2086p pd=1.5u as=0.2128p ps=1.5u w=1.12u l=0.13u
.ends

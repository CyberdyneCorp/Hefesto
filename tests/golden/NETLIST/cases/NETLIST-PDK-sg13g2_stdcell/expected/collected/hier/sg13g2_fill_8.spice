* NGSPICE file created from sg13g2_fill_8.ext - technology: ihp-sg13g2

.subckt sg13g2_fill_8 VDD VSS
.ends

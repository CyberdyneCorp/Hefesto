* NGSPICE file created from sg13g2_einvn_2.ext - technology: ihp-sg13g2

.subckt sg13g2_einvn_2 VDD TE_B VSS A Z
X0 a_210_114# TE_B VSS VSS sg13_lv_nmos ad=0.1449p pd=1.53u as=0.1428p ps=1.52u w=0.42u l=0.13u
X1 a_322_412# A Z VDD sg13_lv_pmos ad=0.3808p pd=2.92u as=0.2128p ps=1.5u w=1.12u l=0.13u
X2 VSS a_210_114# a_322_114# VSS sg13_lv_nmos ad=0.1406p pd=1.12u as=0.2516p ps=2.16u w=0.74u l=0.13u
X3 a_210_114# TE_B VDD VDD sg13_lv_pmos ad=0.2176p pd=1.96u as=0.2176p ps=1.96u w=0.64u l=0.13u
X4 a_322_114# a_210_114# VSS VSS sg13_lv_nmos ad=0.1406p pd=1.12u as=0.1406p ps=1.12u w=0.74u l=0.13u
X5 Z A a_322_114# VSS sg13_lv_nmos ad=0.1443p pd=1.13u as=0.1406p ps=1.12u w=0.74u l=0.13u
X6 VDD TE_B a_322_412# VDD sg13_lv_pmos ad=0.2128p pd=1.5u as=0.3808p ps=2.92u w=1.12u l=0.13u
X7 a_322_412# TE_B VDD VDD sg13_lv_pmos ad=0.2128p pd=1.5u as=0.2128p ps=1.5u w=1.12u l=0.13u
X8 Z A a_322_412# VDD sg13_lv_pmos ad=0.2128p pd=1.5u as=0.2128p ps=1.5u w=1.12u l=0.13u
X9 a_322_114# A Z VSS sg13_lv_nmos ad=0.2516p pd=2.16u as=0.1443p ps=1.13u w=0.74u l=0.13u
.ends

* NGSPICE file created from sg13g2_fill_4.ext - technology: ihp-sg13g2

.subckt sg13g2_fill_4 VDD VSS
.ends

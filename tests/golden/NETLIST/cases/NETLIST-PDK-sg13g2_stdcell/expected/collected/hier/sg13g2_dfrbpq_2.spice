* NGSPICE file created from sg13g2_dfrbpq_2.ext - technology: ihp-sg13g2

.subckt sg13g2_dfrbpq_2 VDD D Q CLK VSS RESET_B
X0 VDD RESET_B a_298_337# VDD sg13_lv_pmos ad=0.1563p pd=1.22u as=0.147p ps=1.54u w=0.42u l=0.13u
X1 Q a_2186_429# VSS VSS sg13_lv_nmos ad=0.14245p pd=1.125u as=0.2516p ps=2.16u w=0.74u l=0.13u
X2 VSS RESET_B a_132_114# VSS sg13_lv_nmos ad=0.1626p pd=1.415u as=60.89999f ps=0.71u w=0.42u l=0.13u
X3 VDD a_1583_191# a_1811_331# VDD sg13_lv_pmos ad=0.9956p pd=6.25u as=79.8f ps=0.8u w=0.42u l=0.13u
X4 VSS a_733_371# a_835_458# VSS sg13_lv_nmos ad=2.45365p pd=15.675u as=0.2516p ps=2.16u w=0.74u l=0.13u
X5 a_733_371# CLK VDD VDD sg13_lv_pmos ad=0.3808p pd=2.92u as=1.19473p ps=7.5u w=1.12u l=0.13u
X6 a_550_127# RESET_B VSS VSS sg13_lv_nmos ad=38.85f pd=0.605u as=0.1701p ps=1.65u w=0.42u l=0.13u
X7 a_613_127# a_324_432# a_550_127# VSS sg13_lv_nmos ad=0.1596p pd=1.6u as=38.85f ps=0.605u w=0.42u l=0.13u
X8 a_2186_429# a_1583_191# VDD VDD sg13_lv_pmos ad=0.34p pd=2.68u as=0.9956p ps=6.25u w=1u l=0.13u
X9 a_1811_331# a_1583_191# a_2002_114# VSS sg13_lv_nmos ad=0.1428p pd=1.52u as=37.8f ps=0.6u w=0.42u l=0.13u
X10 a_1772_429# a_835_458# a_1583_191# VDD sg13_lv_pmos ad=52.5f pd=0.67u as=0.19115p ps=1.565u w=0.42u l=0.13u
X11 a_733_371# CLK VSS VSS sg13_lv_nmos ad=0.2516p pd=2.16u as=2.45365p ps=15.675u w=0.74u l=0.13u
X12 a_38_114# D VDD VDD sg13_lv_pmos ad=79.8f pd=0.8u as=0.1428p ps=1.52u w=0.42u l=0.13u
X13 a_1811_331# RESET_B VDD VDD sg13_lv_pmos ad=79.8f pd=0.8u as=1.19473p ps=7.5u w=0.42u l=0.13u
X14 VSS a_1811_331# a_1489_191# VSS sg13_lv_nmos ad=79.8f pd=0.8u as=0.1428p ps=1.52u w=0.42u l=0.13u
X15 VSS a_2186_429# Q VSS sg13_lv_nmos ad=0.2516p pd=2.16u as=0.14245p ps=1.125u w=0.74u l=0.13u
X16 VDD RESET_B a_38_114# VDD sg13_lv_pmos ad=0.36237p pd=2.605u as=79.8f ps=0.8u w=0.42u l=0.13u
X17 a_324_432# a_298_337# VSS VSS sg13_lv_nmos ad=0.2516p pd=2.16u as=0.1626p ps=1.415u w=0.74u l=0.13u
X18 VDD a_733_371# a_835_458# VDD sg13_lv_pmos ad=1.19473p pd=7.5u as=0.3864p ps=2.93u w=1.12u l=0.13u
X19 a_2002_114# RESET_B VSS VSS sg13_lv_nmos ad=37.8f pd=0.6u as=79.8f ps=0.8u w=0.42u l=0.13u
X20 a_132_114# D a_38_114# VSS sg13_lv_nmos ad=60.89999f pd=0.71u as=0.1428p ps=1.52u w=0.42u l=0.13u
X21 Q a_2186_429# VDD VDD sg13_lv_pmos ad=0.2156p pd=1.505u as=0.3808p ps=2.92u w=1.12u l=0.13u
X22 a_2186_429# a_1583_191# VSS VSS sg13_lv_nmos ad=0.2176p pd=1.96u as=0.2176p ps=1.96u w=0.64u l=0.13u
X23 VDD a_1811_331# a_1772_429# VDD sg13_lv_pmos ad=1.19473p pd=7.5u as=52.5f ps=0.67u w=0.42u l=0.13u
X24 VDD a_2186_429# Q VDD sg13_lv_pmos ad=0.3808p pd=2.92u as=0.2156p ps=1.505u w=1.12u l=0.13u
X25 a_1583_191# a_733_371# a_324_432# VDD sg13_lv_pmos ad=0.19115p pd=1.565u as=0.34p ps=2.68u w=1u l=0.13u
X26 a_1583_191# a_733_371# a_1489_191# VSS sg13_lv_nmos ad=0.12665p pd=1.145u as=0.1428p ps=1.52u w=0.42u l=0.13u
X27 a_298_337# a_733_371# a_681_505# VDD sg13_lv_pmos ad=79.8f pd=0.8u as=54.6f ps=0.68u w=0.42u l=0.13u
X28 a_38_114# a_835_458# a_298_337# VDD sg13_lv_pmos ad=0.1428p pd=1.52u as=79.8f ps=0.8u w=0.42u l=0.13u
X29 a_324_432# a_835_458# a_1583_191# VSS sg13_lv_nmos ad=0.3473p pd=2.71u as=0.12665p ps=1.145u w=0.74u l=0.13u
X30 a_298_337# a_733_371# a_38_114# VSS sg13_lv_nmos ad=81f pd=0.81u as=0.1296p ps=1.52u w=0.42u l=0.13u
X31 a_681_505# a_324_432# VDD VDD sg13_lv_pmos ad=54.6f pd=0.68u as=0.1563p ps=1.22u w=0.42u l=0.13u
X32 a_613_127# a_835_458# a_298_337# VSS sg13_lv_nmos ad=0.2163p pd=1.87u as=81f ps=0.81u w=0.42u l=0.13u
X33 a_324_432# a_298_337# VDD VDD sg13_lv_pmos ad=0.34p pd=2.68u as=0.36237p ps=2.605u w=1u l=0.13u
.ends

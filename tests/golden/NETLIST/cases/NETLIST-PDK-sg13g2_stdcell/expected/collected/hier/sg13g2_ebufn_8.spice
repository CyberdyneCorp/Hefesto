* NGSPICE file created from sg13g2_ebufn_8.ext - technology: ihp-sg13g2

.subckt sg13g2_ebufn_8 VDD VSS Z A TE_B
X0 a_28_418# TE_B VDD VDD sg13_lv_pmos ad=0.2128p pd=1.5u as=0.2128p ps=1.5u w=1.12u l=0.13u
X1 VSS a_925_88# a_27_124# VSS sg13_lv_nmos ad=0.1406p pd=1.12u as=0.16465p ps=1.185u w=0.74u l=0.13u
X2 VDD TE_B a_28_418# VDD sg13_lv_pmos ad=2.1094p pd=13.98u as=0.2128p ps=1.5u w=1.12u l=0.13u
X3 a_27_124# a_96_88# Z VSS sg13_lv_nmos ad=0.1406p pd=1.12u as=0.1406p ps=1.12u w=0.74u l=0.13u
X4 a_27_124# a_925_88# VSS VSS sg13_lv_nmos ad=0.1406p pd=1.12u as=0.1406p ps=1.12u w=0.74u l=0.13u
X5 Z a_96_88# a_28_418# VDD sg13_lv_pmos ad=0.2128p pd=1.5u as=0.2128p ps=1.5u w=1.12u l=0.13u
X6 Z a_96_88# a_28_418# VDD sg13_lv_pmos ad=0.2128p pd=1.5u as=0.3808p ps=2.92u w=1.12u l=0.13u
X7 a_28_418# TE_B VDD VDD sg13_lv_pmos ad=0.3808p pd=2.92u as=2.1094p ps=13.98u w=1.12u l=0.13u
X8 VSS a_925_88# a_27_124# VSS sg13_lv_nmos ad=0.1406p pd=1.12u as=0.1406p ps=1.12u w=0.74u l=0.13u
X9 a_27_124# a_925_88# VSS VSS sg13_lv_nmos ad=0.1406p pd=1.12u as=0.1406p ps=1.12u w=0.74u l=0.13u
X10 a_28_418# a_96_88# Z VDD sg13_lv_pmos ad=0.2128p pd=1.5u as=0.2128p ps=1.5u w=1.12u l=0.13u
X11 VSS a_925_88# a_27_124# VSS sg13_lv_nmos ad=0.1406p pd=1.12u as=0.1406p ps=1.12u w=0.74u l=0.13u
X12 Z a_96_88# a_28_418# VDD sg13_lv_pmos ad=0.2128p pd=1.5u as=0.2128p ps=1.5u w=1.12u l=0.13u
X13 a_27_124# a_925_88# VSS VSS sg13_lv_nmos ad=0.1406p pd=1.12u as=0.1406p ps=1.12u w=0.74u l=0.13u
X14 a_28_418# a_96_88# Z VDD sg13_lv_pmos ad=0.2128p pd=1.5u as=0.2128p ps=1.5u w=1.12u l=0.13u
X15 VDD TE_B a_925_88# VDD sg13_lv_pmos ad=0.2128p pd=1.5u as=0.3808p ps=2.92u w=1.12u l=0.13u
X16 VSS a_925_88# a_27_124# VSS sg13_lv_nmos ad=0.1406p pd=1.12u as=0.1406p ps=1.12u w=0.74u l=0.13u
X17 Z a_96_88# a_28_418# VDD sg13_lv_pmos ad=0.2128p pd=1.5u as=0.2128p ps=1.5u w=1.12u l=0.13u
X18 a_28_418# a_96_88# Z VDD sg13_lv_pmos ad=0.2128p pd=1.5u as=0.2128p ps=1.5u w=1.12u l=0.13u
X19 Z a_96_88# a_27_124# VSS sg13_lv_nmos ad=0.1406p pd=1.12u as=0.1406p ps=1.12u w=0.74u l=0.13u
X20 a_96_88# A VDD VDD sg13_lv_pmos ad=0.2128p pd=1.5u as=0.2128p ps=1.5u w=1.12u l=0.13u
X21 Z a_96_88# a_27_124# VSS sg13_lv_nmos ad=0.1406p pd=1.12u as=0.2553p ps=2.17u w=0.74u l=0.13u
X22 a_27_124# a_925_88# VSS VSS sg13_lv_nmos ad=0.2516p pd=2.16u as=0.1406p ps=1.12u w=0.74u l=0.13u
X23 VDD TE_B a_28_418# VDD sg13_lv_pmos ad=0.2128p pd=1.5u as=0.2128p ps=1.5u w=1.12u l=0.13u
X24 a_27_124# a_96_88# Z VSS sg13_lv_nmos ad=0.1406p pd=1.12u as=0.1406p ps=1.12u w=0.74u l=0.13u
X25 VDD A a_96_88# VDD sg13_lv_pmos ad=0.3808p pd=2.92u as=0.2128p ps=1.5u w=1.12u l=0.13u
X26 Z a_96_88# a_27_124# VSS sg13_lv_nmos ad=0.1406p pd=1.12u as=0.1406p ps=1.12u w=0.74u l=0.13u
X27 a_27_124# a_96_88# Z VSS sg13_lv_nmos ad=0.1406p pd=1.12u as=0.1406p ps=1.12u w=0.74u l=0.13u
X28 a_28_418# TE_B VDD VDD sg13_lv_pmos ad=0.2128p pd=1.5u as=0.2128p ps=1.5u w=1.12u l=0.13u
X29 Z a_96_88# a_27_124# VSS sg13_lv_nmos ad=0.1406p pd=1.12u as=0.1406p ps=1.12u w=0.74u l=0.13u
X30 VSS TE_B a_925_88# VSS sg13_lv_nmos ad=0.1406p pd=1.12u as=0.2516p ps=2.16u w=0.74u l=0.13u
X31 VDD TE_B a_28_418# VDD sg13_lv_pmos ad=0.2156p pd=1.505u as=0.2128p ps=1.5u w=1.12u l=0.13u
X32 a_27_124# a_96_88# Z VSS sg13_lv_nmos ad=0.16465p pd=1.185u as=0.1406p ps=1.12u w=0.74u l=0.13u
X33 a_96_88# A VSS VSS sg13_lv_nmos ad=0.1406p pd=1.12u as=0.1406p ps=1.12u w=0.74u l=0.13u
X34 VSS A a_96_88# VSS sg13_lv_nmos ad=0.2516p pd=2.16u as=0.1406p ps=1.12u w=0.74u l=0.13u
X35 a_28_418# a_96_88# Z VDD sg13_lv_pmos ad=0.2128p pd=1.5u as=0.2128p ps=1.5u w=1.12u l=0.13u
X36 a_28_418# TE_B VDD VDD sg13_lv_pmos ad=0.2128p pd=1.5u as=0.2156p ps=1.505u w=1.12u l=0.13u
X37 VDD TE_B a_28_418# VDD sg13_lv_pmos ad=0.2128p pd=1.5u as=0.2128p ps=1.5u w=1.12u l=0.13u
.ends

* NGSPICE file created from sg13g2_ebufn_2.ext - technology: ihp-sg13g2

.subckt sg13g2_ebufn_2 A Z VSS VDD TE_B
X0 Z a_114_72# a_62_412# VDD sg13_lv_pmos ad=0.2128p pd=1.5u as=0.3808p ps=2.92u w=1.12u l=0.13u
X1 a_114_72# A VDD VDD sg13_lv_pmos ad=0.36p pd=2.72u as=0.28565p ps=1.655u w=1u l=0.13u
X2 a_62_412# a_114_72# Z VDD sg13_lv_pmos ad=0.2128p pd=1.5u as=0.2128p ps=1.5u w=1.12u l=0.13u
X3 VDD TE_B a_318_72# VDD sg13_lv_pmos ad=0.28565p pd=1.655u as=0.34p ps=2.68u w=1u l=0.13u
X4 VDD TE_B a_62_412# VDD sg13_lv_pmos ad=1.0339p pd=6.81u as=0.2128p ps=1.5u w=1.12u l=0.13u
X5 a_62_412# TE_B VDD VDD sg13_lv_pmos ad=0.3808p pd=2.92u as=1.0339p ps=6.81u w=1.12u l=0.13u
X6 VSS TE_B a_318_72# VSS sg13_lv_nmos ad=0.1216p pd=1.02u as=0.2176p ps=1.96u w=0.64u l=0.13u
X7 Z a_114_72# a_46_108# VSS sg13_lv_nmos ad=0.1406p pd=1.12u as=0.2516p ps=2.16u w=0.74u l=0.13u
X8 a_114_72# A VSS VSS sg13_lv_nmos ad=0.2176p pd=1.96u as=0.1216p ps=1.02u w=0.64u l=0.13u
X9 a_46_108# a_114_72# Z VSS sg13_lv_nmos ad=0.1406p pd=1.12u as=0.1406p ps=1.12u w=0.74u l=0.13u
X10 VSS a_318_72# a_46_108# VSS sg13_lv_nmos ad=0.1406p pd=1.12u as=0.1406p ps=1.12u w=0.74u l=0.13u
X11 a_46_108# a_318_72# VSS VSS sg13_lv_nmos ad=0.2516p pd=2.16u as=0.1406p ps=1.12u w=0.74u l=0.13u
.ends

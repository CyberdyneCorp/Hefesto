* NGSPICE file created from sg13g2_sdfbbp_1.ext - technology: ihp-sg13g2

.subckt sg13g2_sdfbbp_1 D Q SCD SCE CLK VDD VSS SET_B RESET_B Q_N
X0 VDD SCD a_64_504# VDD sg13_lv_pmos ad=0.1216p pd=1.02u as=0.2176p ps=1.96u w=0.64u l=0.13u
X1 VDD a_2128_482# a_3023_114# VDD sg13_lv_pmos ad=0.1918p pd=1.5u as=0.2856p ps=2.36u w=0.84u l=0.13u
X2 a_2148_114# a_698_136# a_1962_460# VSS sg13_lv_nmos ad=79.8f pd=0.8u as=0.15327p ps=1.255u w=0.42u l=0.13u
X3 a_399_123# SCE VSS VSS sg13_lv_nmos ad=0.1428p pd=1.52u as=0.14175p ps=1.095u w=0.42u l=0.13u
X4 a_2070_544# a_942_136# a_1962_460# VDD sg13_lv_pmos ad=64.05f pd=0.725u as=0.1575p ps=1.25u w=0.42u l=0.13u
X5 a_260_504# SCE VDD VDD sg13_lv_pmos ad=0.1248p pd=1.03u as=0.1216p ps=1.02u w=0.64u l=0.13u
X6 VDD CLK a_698_136# VDD sg13_lv_pmos ad=0.2128p pd=1.5u as=0.3808p ps=2.92u w=1.12u l=0.13u
X7 a_1179_136# a_942_136# a_260_159# VDD sg13_lv_pmos ad=0.10785p pd=1.02u as=0.2176p ps=1.96u w=0.64u l=0.13u
X8 VSS a_2128_482# a_2148_114# VSS sg13_lv_nmos ad=0.1405p pd=1.15u as=79.8f ps=0.8u w=0.42u l=0.13u
X9 VSS CLK a_698_136# VSS sg13_lv_nmos ad=2.8395p pd=18.65u as=0.2516p ps=2.16u w=0.74u l=0.13u
X10 VSS a_2128_482# a_3023_114# VSS sg13_lv_nmos ad=0.15245p pd=1.17u as=0.187p ps=1.78u w=0.55u l=0.13u
X11 a_942_136# a_698_136# VDD VDD sg13_lv_pmos ad=0.3976p pd=2.95u as=0.2128p ps=1.5u w=1.12u l=0.13u
X12 a_1303_459# a_698_136# a_1179_136# VDD sg13_lv_pmos ad=37.8f pd=0.6u as=0.10785p ps=1.02u w=0.42u l=0.13u
X13 a_1339_271# SET_B VDD VDD sg13_lv_pmos ad=0.2856p pd=1.52u as=0.1977p ps=1.41u w=0.84u l=0.13u
X14 a_1505_165# SET_B VSS VSS sg13_lv_nmos ad=0.2008p pd=1.385u as=0.19065p ps=1.43u w=0.55u l=0.13u
X15 a_1964_159# a_1339_271# VSS VSS sg13_lv_nmos ad=49.5f pd=0.73u as=0.187p ps=1.78u w=0.55u l=0.13u
X16 a_2358_114# SET_B VSS VSS sg13_lv_nmos ad=0.1406p pd=1.12u as=0.1405p ps=1.15u w=0.74u l=0.13u
X17 Q a_3023_114# VSS VSS sg13_lv_nmos ad=0.2516p pd=2.16u as=0.15245p ps=1.17u w=0.74u l=0.13u
X18 a_2128_482# a_1962_460# a_2358_114# VSS sg13_lv_nmos ad=0.1406p pd=1.12u as=0.1406p ps=1.12u w=0.74u l=0.13u
X19 VDD a_1339_271# a_1303_459# VDD sg13_lv_pmos ad=0.1977p pd=1.41u as=37.8f ps=0.6u w=0.42u l=0.13u
X20 a_2358_114# a_1715_123# a_2128_482# VSS sg13_lv_nmos ad=0.2516p pd=2.16u as=0.1406p ps=1.12u w=0.74u l=0.13u
X21 a_399_123# SCE VDD VDD sg13_lv_pmos ad=0.2176p pd=1.96u as=0.2176p ps=1.96u w=0.64u l=0.13u
X22 a_2479_432# a_1962_460# a_2128_482# VDD sg13_lv_pmos ad=89.99999f pd=1.18u as=0.24p ps=1.48u w=1u l=0.13u
X23 a_158_159# SCD VSS VSS sg13_lv_nmos ad=79.8f pd=0.8u as=0.1428p ps=1.52u w=0.42u l=0.13u
X24 a_260_159# SCE a_158_159# VSS sg13_lv_nmos ad=79.8f pd=0.8u as=79.8f ps=0.8u w=0.42u l=0.13u
X25 VDD a_1715_123# a_2479_432# VDD sg13_lv_pmos ad=0.34p pd=2.68u as=89.99999f ps=1.18u w=1u l=0.13u
X26 VDD a_2128_482# a_2070_544# VDD sg13_lv_pmos ad=0.306p pd=2.01u as=64.05f ps=0.725u w=0.42u l=0.13u
X27 Q_N a_2128_482# VSS VSS sg13_lv_nmos ad=0.2516p pd=2.16u as=0.1254p ps=1.12u w=0.74u l=0.13u
X28 a_260_159# D a_260_504# VDD sg13_lv_pmos ad=0.1248p pd=1.03u as=0.1248p ps=1.03u w=0.64u l=0.13u
X29 a_362_159# D a_260_159# VSS sg13_lv_nmos ad=38.85f pd=0.605u as=79.8f ps=0.8u w=0.42u l=0.13u
X30 VSS a_399_123# a_362_159# VSS sg13_lv_nmos ad=0.14175p pd=1.095u as=38.85f ps=0.605u w=0.42u l=0.13u
X31 a_1962_460# a_698_136# a_1853_419# VDD sg13_lv_pmos ad=0.1575p pd=1.25u as=0.1866p ps=1.46u w=0.84u l=0.13u
X32 VDD RESET_B a_1715_123# VDD sg13_lv_pmos ad=0.2128p pd=1.53u as=0.2304p ps=2u w=0.64u l=0.13u
X33 Q a_3023_114# VDD VDD sg13_lv_pmos ad=0.3808p pd=2.92u as=0.1918p ps=1.5u w=1.12u l=0.13u
X34 Q_N a_2128_482# VDD VDD sg13_lv_pmos ad=0.3808p pd=2.92u as=0.2128p ps=1.53u w=1.12u l=0.13u
X35 a_1339_271# a_1179_136# a_1505_165# VSS sg13_lv_nmos ad=0.1045p pd=0.93u as=0.2008p ps=1.385u w=0.55u l=0.13u
X36 a_1179_136# a_698_136# a_260_159# VSS sg13_lv_nmos ad=79.8f pd=0.8u as=0.1428p ps=1.52u w=0.42u l=0.13u
X37 a_1505_165# a_1715_123# a_1339_271# VSS sg13_lv_nmos ad=0.283p pd=2.37u as=0.1045p ps=0.93u w=0.55u l=0.13u
X38 VSS a_1339_271# a_1281_136# VSS sg13_lv_nmos ad=0.19065p pd=1.43u as=74.59999f ps=0.865u w=0.42u l=0.13u
X39 a_942_136# a_698_136# VSS VSS sg13_lv_nmos ad=0.2516p pd=2.16u as=2.8395p ps=18.65u w=0.74u l=0.13u
X40 VDD a_1715_123# a_1667_419# VDD sg13_lv_pmos ad=0.1596p pd=1.22u as=0.1218p ps=1.13u w=0.84u l=0.13u
X41 a_1281_136# a_942_136# a_1179_136# VSS sg13_lv_nmos ad=74.59999f pd=0.865u as=79.8f ps=0.8u w=0.42u l=0.13u
X42 a_2128_482# SET_B VDD VDD sg13_lv_pmos ad=0.24p pd=1.48u as=0.306p ps=2.01u w=1u l=0.13u
X43 a_64_504# a_399_123# a_260_159# VDD sg13_lv_pmos ad=0.2176p pd=1.96u as=0.1248p ps=1.03u w=0.64u l=0.13u
X44 a_1667_419# a_1179_136# a_1339_271# VDD sg13_lv_pmos ad=0.1218p pd=1.13u as=0.2856p ps=1.52u w=0.84u l=0.13u
X45 a_1853_419# a_1339_271# VDD VDD sg13_lv_pmos ad=0.1866p pd=1.46u as=0.1596p ps=1.22u w=0.84u l=0.13u
X46 a_1962_460# a_942_136# a_1964_159# VSS sg13_lv_nmos ad=0.15327p pd=1.255u as=49.5f ps=0.73u w=0.55u l=0.13u
X47 VSS RESET_B a_1715_123# VSS sg13_lv_nmos ad=0.1254p pd=1.12u as=0.1428p ps=1.52u w=0.42u l=0.13u
.ends

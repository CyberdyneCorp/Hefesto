* NGSPICE file created from sg13g2_nand2_2.ext - technology: ihp-sg13g2

.subckt sg13g2_nand2_2 Y VDD A VSS B
X0 VSS B a_57_115# VSS sg13_lv_nmos ad=0.1368p pd=1.1u as=0.27p ps=2.19u w=0.72u l=0.13u
X1 a_57_115# B VSS VSS sg13_lv_nmos ad=0.1404p pd=1.11u as=0.1368p ps=1.1u w=0.72u l=0.13u
X2 Y B VDD VDD sg13_lv_pmos ad=0.2128p pd=1.5u as=0.4032p ps=2.96u w=1.12u l=0.13u
X3 VDD B Y VDD sg13_lv_pmos ad=0.2184p pd=1.51u as=0.2128p ps=1.5u w=1.12u l=0.13u
X4 Y A a_57_115# VSS sg13_lv_nmos ad=0.1368p pd=1.1u as=0.1404p ps=1.11u w=0.72u l=0.13u
X5 a_57_115# A Y VSS sg13_lv_nmos ad=0.2448p pd=2.12u as=0.1368p ps=1.1u w=0.72u l=0.13u
X6 Y A VDD VDD sg13_lv_pmos ad=0.2128p pd=1.5u as=0.2184p ps=1.51u w=1.12u l=0.13u
X7 VDD A Y VDD sg13_lv_pmos ad=0.392p pd=2.94u as=0.2128p ps=1.5u w=1.12u l=0.13u
.ends

* NGSPICE file created from sg13g2_mux4_1.ext - technology: ihp-sg13g2

.subckt sg13g2_mux4_1 X A1 A2 S0 VDD VSS S1 A0 A3
X0 a_886_118# a_1453_124# a_1377_160# VDD sg13_lv_pmos ad=0.34p pd=2.68u as=0.2225p ps=1.445u w=1u l=0.13u
X1 a_886_118# a_71_118# a_810_118# VSS sg13_lv_nmos ad=0.1776p pd=1.195u as=80f ps=0.89u w=0.64u l=0.13u
X2 VDD S0 a_71_118# VDD sg13_lv_pmos ad=0.22315p pd=1.555u as=0.34p ps=2.68u w=1u l=0.13u
X3 X a_1377_160# VSS VSS sg13_lv_nmos ad=0.2516p pd=2.16u as=0.1543p ps=1.18u w=0.74u l=0.13u
X4 X a_1377_160# VDD VDD sg13_lv_pmos ad=0.3808p pd=2.92u as=0.34367p ps=1.775u w=1.12u l=0.13u
X5 a_1023_118# S0 a_886_118# VSS sg13_lv_nmos ad=76.8f pd=0.88u as=0.1776p ps=1.195u w=0.64u l=0.13u
X6 VSS S1 a_1453_124# VSS sg13_lv_nmos ad=0.1543p pd=1.18u as=0.2304p ps=2u w=0.64u l=0.13u
X7 VSS A3 a_1023_118# VSS sg13_lv_nmos ad=0.2176p pd=1.96u as=76.8f ps=0.88u w=0.64u l=0.13u
X8 VSS S0 a_71_118# VSS sg13_lv_nmos ad=0.1872p pd=1.225u as=0.2176p ps=1.96u w=0.64u l=0.13u
X9 a_810_118# A2 VSS VSS sg13_lv_nmos ad=80f pd=0.89u as=0.1824p ps=1.21u w=0.64u l=0.13u
X10 a_886_118# S0 a_805_385# VDD sg13_lv_pmos ad=0.4425p pd=1.885u as=0.20762p ps=1.605u w=1u l=0.13u
X11 VDD S1 a_1453_124# VDD sg13_lv_pmos ad=0.34367p pd=1.775u as=0.34p ps=2.68u w=1u l=0.13u
X12 a_382_118# S0 a_295_385# VDD sg13_lv_pmos ad=0.19p pd=1.38u as=0.415p ps=1.83u w=1u l=0.13u
X13 VDD A1 a_589_385# VDD sg13_lv_pmos ad=0.29275p pd=1.785u as=0.16p ps=1.32u w=1u l=0.13u
X14 a_1109_431# a_71_118# a_886_118# VDD sg13_lv_pmos ad=0.135p pd=1.27u as=0.4425p ps=1.885u w=1u l=0.13u
X15 a_295_385# A0 VDD VDD sg13_lv_pmos ad=0.415p pd=1.83u as=0.22315p ps=1.555u w=1u l=0.13u
X16 a_1377_160# S1 a_382_118# VDD sg13_lv_pmos ad=0.2225p pd=1.445u as=0.34p ps=2.68u w=1u l=0.13u
X17 a_308_118# A0 VSS VSS sg13_lv_nmos ad=76.8f pd=0.88u as=0.1872p ps=1.225u w=0.64u l=0.13u
X18 a_500_118# S0 a_382_118# VSS sg13_lv_nmos ad=0.2304p pd=1.36u as=0.1472p ps=1.1u w=0.64u l=0.13u
X19 a_589_385# a_71_118# a_382_118# VDD sg13_lv_pmos ad=0.16p pd=1.32u as=0.19p ps=1.38u w=1u l=0.13u
X20 a_1377_160# S1 a_886_118# VSS sg13_lv_nmos ad=0.1216p pd=1.02u as=0.54188p ps=3.42u w=0.64u l=0.13u
X21 a_382_118# a_71_118# a_308_118# VSS sg13_lv_nmos ad=0.1472p pd=1.1u as=76.8f ps=0.88u w=0.64u l=0.13u
X22 VSS A1 a_500_118# VSS sg13_lv_nmos ad=0.1824p pd=1.21u as=0.2304p ps=1.36u w=0.64u l=0.13u
X23 VDD A3 a_1109_431# VDD sg13_lv_pmos ad=0.34p pd=2.68u as=0.135p ps=1.27u w=1u l=0.13u
X24 a_382_118# a_1453_124# a_1377_160# VSS sg13_lv_nmos ad=0.2176p pd=1.96u as=0.1216p ps=1.02u w=0.64u l=0.13u
X25 a_805_385# A2 VDD VDD sg13_lv_pmos ad=0.20762p pd=1.605u as=0.29275p ps=1.785u w=1u l=0.13u
.ends

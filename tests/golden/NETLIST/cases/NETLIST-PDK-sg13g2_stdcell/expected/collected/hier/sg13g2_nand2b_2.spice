* NGSPICE file created from sg13g2_nand2b_2.ext - technology: ihp-sg13g2

.subckt sg13g2_nand2b_2 A_N Y VDD VSS B
X0 a_116_149# A_N VDD VDD sg13_lv_pmos ad=0.2856p pd=2.36u as=0.2856p ps=2.36u w=0.84u l=0.13u
X1 Y B a_226_115# VSS sg13_lv_nmos ad=0.1368p pd=1.1u as=0.1404p ps=1.11u w=0.72u l=0.13u
X2 a_226_115# B Y VSS sg13_lv_nmos ad=0.2448p pd=2.12u as=0.1368p ps=1.1u w=0.72u l=0.13u
X3 Y B VDD VDD sg13_lv_pmos ad=0.2128p pd=1.5u as=0.2184p ps=1.51u w=1.12u l=0.13u
X4 VDD B Y VDD sg13_lv_pmos ad=0.392p pd=2.94u as=0.2128p ps=1.5u w=1.12u l=0.13u
X5 a_116_149# A_N VSS VSS sg13_lv_nmos ad=0.187p pd=1.78u as=0.187p ps=1.78u w=0.55u l=0.13u
X6 VSS a_116_149# a_226_115# VSS sg13_lv_nmos ad=0.1368p pd=1.1u as=0.2592p ps=2.16u w=0.72u l=0.13u
X7 Y a_116_149# VDD VDD sg13_lv_pmos ad=0.2128p pd=1.5u as=0.4032p ps=2.96u w=1.12u l=0.13u
X8 a_226_115# a_116_149# VSS VSS sg13_lv_nmos ad=0.1404p pd=1.11u as=0.1368p ps=1.1u w=0.72u l=0.13u
X9 VDD a_116_149# Y VDD sg13_lv_pmos ad=0.2184p pd=1.51u as=0.2128p ps=1.5u w=1.12u l=0.13u
.ends

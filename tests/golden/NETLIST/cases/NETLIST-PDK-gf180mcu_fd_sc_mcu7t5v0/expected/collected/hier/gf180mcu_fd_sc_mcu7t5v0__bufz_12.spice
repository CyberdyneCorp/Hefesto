* NGSPICE file created from gf180mcu_fd_sc_mcu7t5v0__bufz_12.ext - technology: gf180mcuD

.subckt gf180mcu_fd_sc_mcu7t5v0__bufz_12 EN I Z VDD VNW VPW VSS
X0 Z a_468_68# VSS VPW nfet_05v0 ad=0.2132p pd=1.34u as=0.2132p ps=1.34u w=0.82u l=0.6u
X1 Z a_468_68# VSS VPW nfet_05v0 ad=0.2132p pd=1.34u as=0.2132p ps=1.34u w=0.82u l=0.6u
X2 VDD I a_476_527# VNW pfet_05v0 ad=0.3055p pd=1.695u as=0.3055p ps=1.695u w=1.175u l=0.5u
X3 VSS I a_468_68# VPW nfet_05v0 ad=0.2132p pd=1.34u as=0.2132p ps=1.34u w=0.82u l=0.6u
X4 a_476_527# EN a_468_68# VPW nfet_05v0 ad=0.6402p pd=3.51u as=0.2132p ps=1.34u w=0.82u l=0.6u
X5 VDD EN a_36_68# VNW pfet_05v0 ad=0.2457p pd=1.465u as=0.4158p ps=2.77u w=0.945u l=0.5u
X6 a_476_527# I VDD VNW pfet_05v0 ad=0.3055p pd=1.695u as=0.3055p ps=1.695u w=1.175u l=0.5u
X7 Z a_468_68# VSS VPW nfet_05v0 ad=0.2132p pd=1.34u as=0.2132p ps=1.34u w=0.82u l=0.6u
X8 VSS EN a_36_68# VPW nfet_05v0 ad=0.2132p pd=1.34u as=0.3608p ps=2.52u w=0.82u l=0.6u
X9 VSS I a_468_68# VPW nfet_05v0 ad=0.2132p pd=1.34u as=0.2132p ps=1.34u w=0.82u l=0.6u
X10 VSS a_468_68# Z VPW nfet_05v0 ad=0.2132p pd=1.34u as=0.2132p ps=1.34u w=0.82u l=0.6u
X11 a_476_527# EN VDD VNW pfet_05v0 ad=0.4347p pd=1.865u as=0.2457p ps=1.465u w=0.945u l=0.5u
X12 VDD I a_476_527# VNW pfet_05v0 ad=0.3055p pd=1.695u as=0.3055p ps=1.695u w=1.175u l=0.5u
X13 VSS I a_468_68# VPW nfet_05v0 ad=0.2132p pd=1.34u as=0.2132p ps=1.34u w=0.82u l=0.6u
X14 a_468_68# I VSS VPW nfet_05v0 ad=0.2132p pd=1.34u as=0.2132p ps=1.34u w=0.82u l=0.6u
X15 Z a_476_527# VDD VNW pfet_05v0 ad=0.3055p pd=1.695u as=0.3055p ps=1.695u w=1.175u l=0.5u
X16 VDD a_476_527# Z VNW pfet_05v0 ad=0.3055p pd=1.695u as=0.3055p ps=1.695u w=1.175u l=0.5u
X17 a_468_68# I VSS VPW nfet_05v0 ad=0.2132p pd=1.34u as=0.2132p ps=1.34u w=0.82u l=0.6u
X18 VSS a_468_68# Z VPW nfet_05v0 ad=0.2132p pd=1.34u as=0.2132p ps=1.34u w=0.82u l=0.6u
X19 VDD a_476_527# Z VNW pfet_05v0 ad=0.3055p pd=1.695u as=0.3055p ps=1.695u w=1.175u l=0.5u
X20 a_468_68# I VSS VPW nfet_05v0 ad=0.2132p pd=1.34u as=0.5988p ps=3.28u w=0.82u l=0.6u
X21 Z a_476_527# VDD VNW pfet_05v0 ad=0.3055p pd=1.695u as=0.3055p ps=1.695u w=1.175u l=0.5u
X22 a_468_68# a_36_68# a_476_527# VNW pfet_05v0 ad=0.4158p pd=2.77u as=0.4347p ps=1.865u w=0.945u l=0.5u
X23 Z a_468_68# VSS VPW nfet_05v0 ad=0.2132p pd=1.34u as=0.2132p ps=1.34u w=0.82u l=0.6u
X24 Z a_476_527# VDD VNW pfet_05v0 ad=0.3055p pd=1.695u as=0.3055p ps=1.695u w=1.175u l=0.5u
X25 VDD a_476_527# Z VNW pfet_05v0 ad=0.3055p pd=1.695u as=0.3055p ps=1.695u w=1.175u l=0.5u
X26 Z a_476_527# VDD VNW pfet_05v0 ad=0.3055p pd=1.695u as=0.3055p ps=1.695u w=1.175u l=0.5u
X27 VSS a_468_68# Z VPW nfet_05v0 ad=0.2132p pd=1.34u as=0.2132p ps=1.34u w=0.82u l=0.6u
X28 Z a_476_527# VDD VNW pfet_05v0 ad=0.3055p pd=1.695u as=0.3055p ps=1.695u w=1.175u l=0.5u
X29 VSS a_468_68# Z VPW nfet_05v0 ad=0.2132p pd=1.34u as=0.2132p ps=1.34u w=0.82u l=0.6u
X30 a_476_527# I VDD VNW pfet_05v0 ad=0.3055p pd=1.695u as=0.517p ps=3.23u w=1.175u l=0.5u
X31 VDD a_476_527# Z VNW pfet_05v0 ad=0.3055p pd=1.695u as=0.3055p ps=1.695u w=1.175u l=0.5u
X32 VSS a_468_68# Z VPW nfet_05v0 ad=0.3608p pd=2.52u as=0.2132p ps=1.34u w=0.82u l=0.6u
X33 VDD a_476_527# Z VNW pfet_05v0 ad=0.3055p pd=1.695u as=0.3055p ps=1.695u w=1.175u l=0.5u
X34 VSS a_468_68# Z VPW nfet_05v0 ad=0.2132p pd=1.34u as=0.2132p ps=1.34u w=0.82u l=0.6u
X35 a_468_68# a_36_68# VSS VPW nfet_05v0 ad=0.2132p pd=1.34u as=0.2132p ps=1.34u w=0.82u l=0.6u
X36 VDD I a_476_527# VNW pfet_05v0 ad=0.3055p pd=1.695u as=0.3055p ps=1.695u w=1.175u l=0.5u
X37 Z a_476_527# VDD VNW pfet_05v0 ad=0.3055p pd=1.695u as=0.3055p ps=1.695u w=1.175u l=0.5u
X38 Z a_468_68# VSS VPW nfet_05v0 ad=0.2132p pd=1.34u as=0.2132p ps=1.34u w=0.82u l=0.6u
X39 a_476_527# I VDD VNW pfet_05v0 ad=0.3055p pd=1.695u as=0.3055p ps=1.695u w=1.175u l=0.5u
X40 VDD a_476_527# Z VNW pfet_05v0 ad=0.517p pd=3.23u as=0.3055p ps=1.695u w=1.175u l=0.5u
X41 Z a_468_68# VSS VPW nfet_05v0 ad=0.2132p pd=1.34u as=0.2132p ps=1.34u w=0.82u l=0.6u
C0 a_476_527# a_468_68# 2.02245f
C1 VNW VPW 8.21278f
.ends

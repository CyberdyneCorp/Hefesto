* NGSPICE file created from gf180mcu_fd_sc_mcu7t5v0__sdffq_1.ext - technology: gf180mcuD

.subckt gf180mcu_fd_sc_mcu7t5v0__sdffq_1 D SE SI CLK Q VDD VNW VPW VSS
X0 a_3284_158# a_1288_135# a_3050_502# VPW nfet_05v0 ad=43.2f pd=0.6u as=93.59999f ps=0.88u w=0.36u l=0.6u
X1 a_2346_502# a_1288_135# a_2132_502# VNW pfet_05v0 ad=0.12285p pd=1.02u as=0.17955p ps=1.2u w=0.63u l=0.5u
X2 a_2424_386# a_2132_502# VSS VPW nfet_05v0 ad=93.59999f pd=0.88u as=0.1449p ps=1.165u w=0.36u l=0.6u
X3 Q a_3312_458# VSS VPW nfet_05v0 ad=0.3586p pd=2.51u as=0.3586p ps=2.51u w=0.815u l=0.6u
X4 a_636_156# SE a_468_156# VPW nfet_05v0 ad=93.59999f pd=0.88u as=43.2f ps=0.6u w=0.36u l=0.6u
X5 a_1751_139# a_1288_135# VSS VPW nfet_05v0 ad=0.3519p pd=2.5u as=0.2046p ps=1.81u w=0.465u l=0.6u
X6 a_1751_139# a_1288_135# VDD VNW pfet_05v0 ad=0.3586p pd=2.51u as=0.69407p ps=3.71u w=0.815u l=0.5u
X7 a_2132_502# a_1751_139# a_596_502# VNW pfet_05v0 ad=0.17955p pd=1.2u as=0.2772p ps=2.14u w=0.63u l=0.5u
X8 a_3264_502# a_1751_139# a_3050_502# VNW pfet_05v0 ad=75.59999f pd=0.87u as=0.17955p ps=1.2u w=0.63u l=0.5u
X9 VSS a_2424_386# a_2387_158# VPW nfet_05v0 ad=0.1449p pd=1.165u as=43.2f ps=0.6u w=0.36u l=0.6u
X10 a_448_502# SI VDD VNW pfet_05v0 ad=75.59999f pd=0.87u as=0.1953p ps=1.25u w=0.63u l=0.5u
X11 a_468_156# SI VSS VPW nfet_05v0 ad=43.2f pd=0.6u as=93.59999f ps=0.88u w=0.36u l=0.6u
X12 a_596_502# a_36_156# a_448_502# VNW pfet_05v0 ad=0.1638p pd=1.15u as=75.59999f ps=0.87u w=0.63u l=0.5u
X13 a_2424_386# a_2132_502# VDD VNW pfet_05v0 ad=0.2079p pd=1.29u as=0.3294p ps=1.74u w=0.63u l=0.51u
X14 a_2387_158# a_1751_139# a_2132_502# VPW nfet_05v0 ad=43.2f pd=0.6u as=93.59999f ps=0.88u w=0.36u l=0.6u
X15 VSS D a_860_156# VPW nfet_05v0 ad=0.147p pd=1.165u as=43.2f ps=0.6u w=0.36u l=0.6u
X16 VDD a_3312_458# a_3264_502# VNW pfet_05v0 ad=0.25665p pd=1.465u as=75.59999f ps=0.87u w=0.63u l=0.5u
X17 a_3312_458# a_3050_502# VSS VPW nfet_05v0 ad=0.1914p pd=1.75u as=0.27225p ps=1.81u w=0.435u l=0.6u
X18 VDD a_2424_386# a_2346_502# VNW pfet_05v0 ad=0.3294p pd=1.74u as=0.12285p ps=1.02u w=0.63u l=0.5u
X19 a_3312_458# a_3050_502# VDD VNW pfet_05v0 ad=0.3102p pd=2.29u as=0.25665p ps=1.465u w=0.705u l=0.5u
X20 a_3050_502# a_1751_139# a_2424_386# VPW nfet_05v0 ad=93.59999f pd=0.88u as=93.59999f ps=0.88u w=0.36u l=0.6u
X21 a_3050_502# a_1288_135# a_2424_386# VNW pfet_05v0 ad=0.17955p pd=1.2u as=0.2079p ps=1.29u w=0.63u l=0.5u
X22 VDD SE a_36_156# VNW pfet_05v0 ad=0.1953p pd=1.25u as=0.2772p ps=2.14u w=0.63u l=0.5u
X23 a_800_502# SE a_596_502# VNW pfet_05v0 ad=0.1386p pd=1.07u as=0.1638p ps=1.15u w=0.63u l=0.5u
X24 a_860_156# a_36_156# a_636_156# VPW nfet_05v0 ad=43.2f pd=0.6u as=93.59999f ps=0.88u w=0.36u l=0.6u
X25 VSS SE a_36_156# VPW nfet_05v0 ad=93.59999f pd=0.88u as=0.1584p ps=1.6u w=0.36u l=0.6u
X26 VDD D a_800_502# VNW pfet_05v0 ad=0.43p pd=1.995u as=0.1386p ps=1.07u w=0.63u l=0.5u
X27 a_1288_135# CLK VSS VPW nfet_05v0 ad=0.3713p pd=2.58u as=0.147p ps=1.165u w=0.465u l=0.6u
X28 VSS a_3312_458# a_3284_158# VPW nfet_05v0 ad=0.27225p pd=1.81u as=43.2f ps=0.6u w=0.36u l=0.6u
X29 a_2132_502# a_1288_135# a_636_156# VPW nfet_05v0 ad=93.59999f pd=0.88u as=0.1584p ps=1.6u w=0.36u l=0.6u
X30 Q a_3312_458# VDD VNW pfet_05v0 ad=0.5346p pd=3.31u as=0.6561p ps=3.51u w=1.215u l=0.5u
X31 a_1288_135# CLK VDD VNW pfet_05v0 ad=0.4048p pd=2.72u as=0.43p ps=1.995u w=0.92u l=0.5u
C0 VNW VPW 6.82479f
.ends

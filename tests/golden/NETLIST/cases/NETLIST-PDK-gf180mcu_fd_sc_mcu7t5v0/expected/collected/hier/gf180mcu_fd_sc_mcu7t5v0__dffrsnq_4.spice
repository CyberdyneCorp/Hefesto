* NGSPICE file created from gf180mcu_fd_sc_mcu7t5v0__dffrsnq_4.ext - technology: gf180mcuD

.subckt gf180mcu_fd_sc_mcu7t5v0__dffrsnq_4 D RN SETN CLK Q VDD VNW VPW VSS
X0 VDD a_3296_112# a_2664_156# VNW pfet_05v0 ad=0.2002p pd=1.29u as=0.2002p ps=1.29u w=0.77u l=0.5u
X1 VSS CLK a_36_151# VPW nfet_05v0 ad=0.1053p pd=0.925u as=0.1782p ps=1.69u w=0.405u l=0.6u
X2 a_2036_156# a_1036_504# VSS VPW nfet_05v0 ad=60.59999f pd=0.745u as=0.3003p ps=1.785u w=0.505u l=0.6u
X3 Q a_3296_112# VSS VPW nfet_05v0 ad=0.2119p pd=1.335u as=0.3586p ps=2.51u w=0.815u l=0.6u
X4 a_1036_504# a_428_472# a_832_504# VNW pfet_05v0 ad=0.1235p pd=0.995u as=0.1235p ps=0.995u w=0.475u l=0.5u
X5 a_3296_112# RN VDD VNW pfet_05v0 ad=0.2002p pd=1.29u as=0.2002p ps=1.29u w=0.77u l=0.5u
X6 a_1524_171# a_1344_416# a_1356_171# VPW nfet_05v0 ad=43.8f pd=0.605u as=43.8f ps=0.605u w=0.365u l=0.6u
X7 VDD a_2440_156# a_3296_112# VNW pfet_05v0 ad=0.3388p pd=2.42u as=0.2002p ps=1.29u w=0.77u l=0.5u
X8 a_1240_504# a_36_151# a_1036_504# VNW pfet_05v0 ad=0.1235p pd=0.995u as=0.1235p ps=0.995u w=0.475u l=0.5u
X9 a_3232_156# SETN a_2664_156# VPW nfet_05v0 ad=60.8f pd=0.7u as=0.1672p ps=1.64u w=0.38u l=0.6u
X10 a_2440_156# a_428_472# a_1344_416# VPW nfet_05v0 ad=0.1313p pd=1.025u as=0.14645p ps=1.085u w=0.505u l=0.6u
X11 a_1356_171# a_428_472# a_1036_504# VPW nfet_05v0 ad=43.8f pd=0.605u as=94.89999f ps=0.885u w=0.365u l=0.6u
X12 a_1344_416# SETN a_2036_156# VPW nfet_05v0 ad=0.14645p pd=1.085u as=60.59999f ps=0.745u w=0.505u l=0.6u
X13 VDD a_1344_416# a_1240_504# VNW pfet_05v0 ad=0.39435p pd=2.18u as=0.1235p ps=0.995u w=0.475u l=0.5u
X14 a_1344_416# SETN VDD VNW pfet_05v0 ad=93.59999f pd=0.88u as=0.3735p ps=2.16u w=0.36u l=0.5u
X15 Q a_3296_112# VDD VNW pfet_05v0 ad=0.3159p pd=1.735u as=0.5346p ps=3.31u w=1.215u l=0.5u
X16 a_2440_156# a_36_151# a_1344_416# VNW pfet_05v0 ad=93.59999f pd=0.88u as=93.59999f ps=0.88u w=0.36u l=0.5u
X17 a_3640_156# RN VSS VPW nfet_05v0 ad=49.4f pd=0.64u as=98.8f ps=0.9u w=0.38u l=0.6u
X18 Q a_3296_112# VSS VPW nfet_05v0 ad=0.2119p pd=1.335u as=0.2119p ps=1.335u w=0.815u l=0.6u
X19 a_1240_504# RN VDD VNW pfet_05v0 ad=0.3036p pd=2.26u as=0.39435p ps=2.18u w=0.69u l=0.5u
X20 VDD a_3296_112# Q VNW pfet_05v0 ad=0.3159p pd=1.735u as=0.3159p ps=1.735u w=1.215u l=0.5u
X21 a_2664_156# a_428_472# a_2440_156# VNW pfet_05v0 ad=0.1584p pd=1.6u as=93.59999f ps=0.88u w=0.36u l=0.5u
X22 VSS a_3296_112# a_3232_156# VPW nfet_05v0 ad=98.8f pd=0.9u as=60.8f ps=0.7u w=0.38u l=0.6u
X23 a_428_472# a_36_151# VSS VPW nfet_05v0 ad=0.1782p pd=1.69u as=0.1053p ps=0.925u w=0.405u l=0.6u
X24 VSS RN a_1524_171# VPW nfet_05v0 ad=0.3003p pd=1.785u as=43.8f ps=0.605u w=0.365u l=0.6u
X25 a_3296_112# a_2440_156# a_3640_156# VPW nfet_05v0 ad=0.1672p pd=1.64u as=49.4f ps=0.64u w=0.38u l=0.6u
X26 VSS a_3296_112# Q VPW nfet_05v0 ad=0.3586p pd=2.51u as=0.2119p ps=1.335u w=0.815u l=0.6u
X27 a_1036_504# a_36_151# a_832_504# VPW nfet_05v0 ad=94.89999f pd=0.885u as=94.89999f ps=0.885u w=0.365u l=0.6u
X28 VSS a_3296_112# Q VPW nfet_05v0 ad=0.2119p pd=1.335u as=0.2119p ps=1.335u w=0.815u l=0.6u
X29 a_832_504# D VSS VPW nfet_05v0 ad=94.89999f pd=0.885u as=0.1606p ps=1.61u w=0.365u l=0.6u
X30 Q a_3296_112# VDD VNW pfet_05v0 ad=0.3159p pd=1.735u as=0.3159p ps=1.735u w=1.215u l=0.5u
X31 VDD CLK a_36_151# VNW pfet_05v0 ad=0.2249p pd=1.385u as=0.3806p ps=2.61u w=0.865u l=0.5u
X32 a_2664_156# a_36_151# a_2440_156# VPW nfet_05v0 ad=0.2222p pd=1.89u as=0.1313p ps=1.025u w=0.505u l=0.6u
X33 a_2664_156# SETN VDD VNW pfet_05v0 ad=0.2002p pd=1.29u as=0.41965p ps=2.63u w=0.77u l=0.5u
X34 VDD a_3296_112# Q VNW pfet_05v0 ad=0.5346p pd=3.31u as=0.3159p ps=1.735u w=1.215u l=0.5u
X35 a_428_472# a_36_151# VDD VNW pfet_05v0 ad=0.3806p pd=2.61u as=0.2249p ps=1.385u w=0.865u l=0.5u
X36 a_832_504# D VDD VNW pfet_05v0 ad=0.1235p pd=0.995u as=0.4701p ps=3u w=0.475u l=0.5u
X37 VDD a_1036_504# a_1344_416# VNW pfet_05v0 ad=0.3735p pd=2.16u as=0.3036p ps=2.26u w=0.69u l=0.5u
C0 VNW VPW 7.934f
.ends

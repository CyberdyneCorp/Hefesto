* NGSPICE file created from gf180mcu_fd_sc_mcu7t5v0__fill_16.ext - technology: gf180mcuD

.subckt gf180mcu_fd_sc_mcu7t5v0__fill_16 VDD VNW VPW VSS
C0 VNW VPW 3.05206f
.ends

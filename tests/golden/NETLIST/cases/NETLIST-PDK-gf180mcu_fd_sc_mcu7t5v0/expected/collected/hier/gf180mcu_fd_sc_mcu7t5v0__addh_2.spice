* NGSPICE file created from gf180mcu_fd_sc_mcu7t5v0__addh_2.ext - technology: gf180mcuD

.subckt gf180mcu_fd_sc_mcu7t5v0__addh_2 A B CO S VDD VNW VPW VSS
X0 VDD a_128_24# a_1272_69# VNW pfet_05v0 ad=0.468p pd=1.935u as=0.30225p ps=1.595u w=0.975u l=0.5u
X1 CO a_128_24# VDD VNW pfet_05v0 ad=0.37665p pd=1.835u as=0.5346p ps=3.31u w=1.215u l=0.5u
X2 a_696_69# A VSS VPW nfet_05v0 ad=0.1304p pd=1.135u as=0.2119p ps=1.335u w=0.815u l=0.6u
X3 CO a_128_24# VSS VPW nfet_05v0 ad=0.2119p pd=1.335u as=0.3586p ps=2.51u w=0.815u l=0.6u
X4 a_1272_69# B a_1064_69# VPW nfet_05v0 ad=0.4137p pd=1.9u as=0.3586p ps=2.51u w=0.815u l=0.6u
X5 VSS a_128_24# a_1064_69# VPW nfet_05v0 ad=0.3097p pd=1.575u as=0.2119p ps=1.335u w=0.815u l=0.6u
X6 a_1272_69# A a_1272_520# VNW pfet_05v0 ad=0.30225p pd=1.595u as=0.468p ps=1.935u w=0.975u l=0.5u
X7 VSS a_128_24# CO VPW nfet_05v0 ad=0.2119p pd=1.335u as=0.2119p ps=1.335u w=0.815u l=0.6u
X8 VSS a_1272_69# S VPW nfet_05v0 ad=0.3586p pd=2.51u as=0.2119p ps=1.335u w=0.815u l=0.6u
X9 S a_1272_69# VSS VPW nfet_05v0 ad=0.2119p pd=1.335u as=0.3097p ps=1.575u w=0.815u l=0.6u
X10 VDD a_1272_69# S VNW pfet_05v0 ad=0.429p pd=2.83u as=0.2535p ps=1.495u w=0.975u l=0.5u
X11 a_128_24# A VDD VNW pfet_05v0 ad=0.3159p pd=1.735u as=0.34627p ps=1.785u w=1.215u l=0.5u
X12 VDD B a_128_24# VNW pfet_05v0 ad=0.5346p pd=3.31u as=0.3159p ps=1.735u w=1.215u l=0.5u
X13 a_1064_69# A a_1272_69# VPW nfet_05v0 ad=0.2119p pd=1.335u as=0.4137p ps=1.9u w=0.815u l=0.6u
X14 a_128_24# B a_696_69# VPW nfet_05v0 ad=0.4564p pd=2.75u as=0.1304p ps=1.135u w=0.815u l=0.6u
X15 VDD a_128_24# CO VNW pfet_05v0 ad=0.34627p pd=1.785u as=0.37665p ps=1.835u w=1.215u l=0.5u
X16 a_1272_520# B VDD VNW pfet_05v0 ad=0.468p pd=1.935u as=0.429p ps=2.83u w=0.975u l=0.5u
X17 S a_1272_69# VDD VNW pfet_05v0 ad=0.2535p pd=1.495u as=0.468p ps=1.935u w=0.975u l=0.5u
C0 VNW VPW 4.07797f
.ends

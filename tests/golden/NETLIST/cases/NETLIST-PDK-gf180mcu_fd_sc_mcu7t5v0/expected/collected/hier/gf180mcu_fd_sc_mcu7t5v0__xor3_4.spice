* NGSPICE file created from gf180mcu_fd_sc_mcu7t5v0__xor3_4.ext - technology: gf180mcuD

.subckt gf180mcu_fd_sc_mcu7t5v0__xor3_4 A1 A2 A3 Z VDD VNW VPW VSS
X0 VSS A3 a_1468_93# VPW nfet_05v0 ad=0.218p pd=1.52u as=57.59999f ps=0.68u w=0.36u l=0.6u
X1 VSS a_1912_497# Z VPW nfet_05v0 ad=0.2132p pd=1.34u as=0.3608p ps=2.52u w=0.82u l=0.6u
X2 a_916_93# A1 a_692_93# VPW nfet_05v0 ad=57.59999f pd=0.68u as=93.59999f ps=0.88u w=0.36u l=0.6u
X3 a_1912_497# A3 a_1912_68# VPW nfet_05v0 ad=0.4161p pd=1.905u as=0.2132p ps=1.34u w=0.82u l=0.6u
X4 a_244_524# A2 a_56_524# VNW pfet_05v0 ad=93.59999f pd=0.88u as=0.1584p ps=1.6u w=0.36u l=0.5u
X5 VSS A1 a_56_524# VPW nfet_05v0 ad=93.59999f pd=0.88u as=93.59999f ps=0.88u w=0.36u l=0.6u
X6 VSS a_1912_497# Z VPW nfet_05v0 ad=0.2132p pd=1.34u as=0.2132p ps=1.34u w=0.82u l=0.6u
X7 a_1912_68# a_1260_93# VSS VPW nfet_05v0 ad=0.2132p pd=1.34u as=0.218p ps=1.52u w=0.82u l=0.6u
X8 Z a_1912_497# VSS VPW nfet_05v0 ad=0.2132p pd=1.34u as=0.2132p ps=1.34u w=0.82u l=0.6u
X9 Z a_1912_497# VDD VNW pfet_05v0 ad=0.3782p pd=1.84u as=0.3477p ps=1.79u w=1.22u l=0.5u
X10 VDD A1 a_244_524# VNW pfet_05v0 ad=0.1346p pd=1.105u as=93.59999f ps=0.88u w=0.36u l=0.5u
X11 a_692_519# a_56_524# VDD VNW pfet_05v0 ad=0.1001p pd=0.905u as=0.1346p ps=1.105u w=0.385u l=0.5u
X12 a_2126_497# A3 a_1912_497# VNW pfet_05v0 ad=0.55297p pd=2.105u as=0.31207p ps=1.665u w=1.095u l=0.5u
X13 a_692_93# a_56_524# VSS VPW nfet_05v0 ad=93.59999f pd=0.88u as=93.59999f ps=0.88u w=0.36u l=0.6u
X14 VDD a_1912_497# Z VNW pfet_05v0 ad=0.3477p pd=1.79u as=0.5368p ps=3.32u w=1.22u l=0.5u
X15 a_692_93# A1 a_692_519# VNW pfet_05v0 ad=0.1001p pd=0.905u as=0.1001p ps=0.905u w=0.385u l=0.5u
X16 Z a_1912_497# VDD VNW pfet_05v0 ad=0.5368p pd=3.32u as=0.3477p ps=1.79u w=1.22u l=0.5u
X17 a_56_524# A2 VSS VPW nfet_05v0 ad=93.59999f pd=0.88u as=0.1584p ps=1.6u w=0.36u l=0.6u
X18 a_1912_68# a_692_93# a_1912_497# VPW nfet_05v0 ad=0.3608p pd=2.52u as=0.4161p ps=1.905u w=0.82u l=0.6u
X19 a_1468_93# a_692_93# a_1260_93# VPW nfet_05v0 ad=57.59999f pd=0.68u as=0.1584p ps=1.6u w=0.36u l=0.6u
X20 a_1260_93# a_692_93# VDD VNW pfet_05v0 ad=93.59999f pd=0.88u as=0.1584p ps=1.6u w=0.36u l=0.5u
X21 VDD A3 a_1260_93# VNW pfet_05v0 ad=0.32775p pd=1.895u as=93.59999f ps=0.88u w=0.36u l=0.5u
X22 VDD a_1912_497# Z VNW pfet_05v0 ad=0.3477p pd=1.79u as=0.3782p ps=1.84u w=1.22u l=0.5u
X23 VSS A2 a_916_93# VPW nfet_05v0 ad=0.1584p pd=1.6u as=57.59999f ps=0.68u w=0.36u l=0.6u
X24 a_1912_497# a_1260_93# VDD VNW pfet_05v0 ad=0.31207p pd=1.665u as=0.32775p ps=1.895u w=1.095u l=0.5u
X25 VDD a_692_93# a_2126_497# VNW pfet_05v0 ad=0.4818p pd=3.07u as=0.55297p ps=2.105u w=1.095u l=0.5u
X26 a_692_519# A2 a_692_93# VNW pfet_05v0 ad=0.1694p pd=1.65u as=0.1001p ps=0.905u w=0.385u l=0.5u
X27 Z a_1912_497# VSS VPW nfet_05v0 ad=0.3608p pd=2.52u as=0.2132p ps=1.34u w=0.82u l=0.6u
C0 VNW VPW 5.99437f
.ends

* NGSPICE file created from gf180mcu_fd_sc_mcu7t5v0__invz_16.ext - technology: gf180mcuD

.subckt gf180mcu_fd_sc_mcu7t5v0__invz_16 EN I ZN VDD VNW VPW VSS
X0 VDD I a_1239_497# VNW pfet_05v0 ad=0.6118p pd=2.24u as=0.58035p ps=2.155u w=1.095u l=0.5u
X1 VDD a_512_497# ZN VNW pfet_05v0 ad=0.3658p pd=1.8u as=0.3363p ps=1.75u w=1.18u l=0.5u
X2 a_489_68# a_1239_497# VSS VPW nfet_05v0 ad=0.2132p pd=1.34u as=0.287p ps=1.52u w=0.82u l=0.6u
X3 a_489_68# a_57_68# a_512_497# VNW pfet_05v0 ad=0.4818p pd=3.07u as=0.2847p ps=1.615u w=1.095u l=0.5u
X4 a_1239_497# I VDD VNW pfet_05v0 ad=0.58035p pd=2.155u as=0.60915p ps=2.315u w=1.095u l=0.5u
X5 VDD a_512_497# ZN VNW pfet_05v0 ad=0.3658p pd=1.8u as=0.3658p ps=1.8u w=1.18u l=0.5u
X6 VSS a_489_68# ZN VPW nfet_05v0 ad=0.2132p pd=1.34u as=0.2132p ps=1.34u w=0.82u l=0.6u
X7 ZN a_512_497# VDD VNW pfet_05v0 ad=0.3658p pd=1.8u as=0.3658p ps=1.8u w=1.18u l=0.5u
X8 ZN a_489_68# VSS VPW nfet_05v0 ad=0.2132p pd=1.34u as=0.2132p ps=1.34u w=0.82u l=0.6u
X9 a_512_497# a_1239_497# VDD VNW pfet_05v0 ad=0.3658p pd=1.8u as=0.6118p ps=2.24u w=1.18u l=0.5u
X10 ZN a_512_497# VDD VNW pfet_05v0 ad=0.3363p pd=1.75u as=0.3953p ps=1.85u w=1.18u l=0.5u
X11 VDD a_512_497# ZN VNW pfet_05v0 ad=0.3658p pd=1.8u as=0.3658p ps=1.8u w=1.18u l=0.5u
X12 ZN a_489_68# VSS VPW nfet_05v0 ad=0.2132p pd=1.34u as=0.2132p ps=1.34u w=0.82u l=0.6u
X13 a_512_497# a_1239_497# VDD VNW pfet_05v0 ad=0.3658p pd=1.8u as=0.472p ps=1.98u w=1.18u l=0.5u
X14 VDD a_512_497# ZN VNW pfet_05v0 ad=0.5192p pd=3.24u as=0.3658p ps=1.8u w=1.18u l=0.5u
X15 a_489_68# a_57_68# VSS VPW nfet_05v0 ad=0.2132p pd=1.34u as=0.2132p ps=1.34u w=0.82u l=0.6u
X16 VSS a_1239_497# a_489_68# VPW nfet_05v0 ad=0.2132p pd=1.34u as=0.2132p ps=1.34u w=0.82u l=0.6u
X17 ZN a_489_68# VSS VPW nfet_05v0 ad=0.2132p pd=1.34u as=0.2132p ps=1.34u w=0.82u l=0.6u
X18 ZN a_512_497# VDD VNW pfet_05v0 ad=0.3658p pd=1.8u as=0.3658p ps=1.8u w=1.18u l=0.5u
X19 VDD a_512_497# ZN VNW pfet_05v0 ad=0.3658p pd=1.8u as=0.3658p ps=1.8u w=1.18u l=0.5u
X20 VDD a_1239_497# a_512_497# VNW pfet_05v0 ad=0.472p pd=1.98u as=0.3658p ps=1.8u w=1.18u l=0.5u
X21 VSS I a_1239_497# VPW nfet_05v0 ad=0.4224p pd=1.94u as=0.4161p ps=1.905u w=0.82u l=0.6u
X22 VSS I a_1239_497# VPW nfet_05v0 ad=0.4224p pd=1.94u as=0.4161p ps=1.905u w=0.82u l=0.6u
X23 a_512_497# EN a_489_68# VPW nfet_05v0 ad=0.5862p pd=3.21u as=0.2132p ps=1.34u w=0.82u l=0.6u
X24 VSS a_1239_497# a_489_68# VPW nfet_05v0 ad=0.287p pd=1.52u as=0.2132p ps=1.34u w=0.82u l=0.6u
X25 a_512_497# a_1239_497# VDD VNW pfet_05v0 ad=0.3658p pd=1.8u as=0.3658p ps=1.8u w=1.18u l=0.5u
X26 VSS a_489_68# ZN VPW nfet_05v0 ad=0.2132p pd=1.34u as=0.2132p ps=1.34u w=0.82u l=0.6u
X27 VDD a_512_497# ZN VNW pfet_05v0 ad=0.3658p pd=1.8u as=0.3658p ps=1.8u w=1.18u l=0.5u
X28 VSS EN a_57_68# VPW nfet_05v0 ad=0.2132p pd=1.34u as=0.3608p ps=2.52u w=0.82u l=0.6u
X29 a_1239_497# I VSS VPW nfet_05v0 ad=0.4161p pd=1.905u as=0.5988p ps=3.28u w=0.82u l=0.6u
X30 VSS a_1239_497# a_489_68# VPW nfet_05v0 ad=0.2132p pd=1.34u as=0.2132p ps=1.34u w=0.82u l=0.6u
X31 a_512_497# a_1239_497# VDD VNW pfet_05v0 ad=0.3658p pd=1.8u as=0.3658p ps=1.8u w=1.18u l=0.5u
X32 ZN a_512_497# VDD VNW pfet_05v0 ad=0.3658p pd=1.8u as=0.3658p ps=1.8u w=1.18u l=0.5u
X33 a_489_68# a_1239_497# VSS VPW nfet_05v0 ad=0.2132p pd=1.34u as=0.2132p ps=1.34u w=0.82u l=0.6u
X34 VSS a_489_68# ZN VPW nfet_05v0 ad=0.3608p pd=2.52u as=0.2132p ps=1.34u w=0.82u l=0.6u
X35 ZN a_512_497# VDD VNW pfet_05v0 ad=0.3658p pd=1.8u as=0.3658p ps=1.8u w=1.18u l=0.5u
X36 VSS a_489_68# ZN VPW nfet_05v0 ad=0.2132p pd=1.34u as=0.2132p ps=1.34u w=0.82u l=0.6u
X37 VDD a_512_497# ZN VNW pfet_05v0 ad=0.3658p pd=1.8u as=0.3658p ps=1.8u w=1.18u l=0.5u
X38 ZN a_489_68# VSS VPW nfet_05v0 ad=0.2132p pd=1.34u as=0.2132p ps=1.34u w=0.82u l=0.6u
X39 ZN a_489_68# VSS VPW nfet_05v0 ad=0.2132p pd=1.34u as=0.2132p ps=1.34u w=0.82u l=0.6u
X40 a_1239_497# I VDD VNW pfet_05v0 ad=0.58035p pd=2.155u as=0.7803p ps=3.83u w=1.095u l=0.5u
X41 ZN a_512_497# VDD VNW pfet_05v0 ad=0.3658p pd=1.8u as=0.3658p ps=1.8u w=1.18u l=0.5u
X42 a_489_68# a_1239_497# VSS VPW nfet_05v0 ad=0.2132p pd=1.34u as=0.4224p ps=1.94u w=0.82u l=0.6u
X43 ZN a_512_497# VDD VNW pfet_05v0 ad=0.3658p pd=1.8u as=0.3658p ps=1.8u w=1.18u l=0.5u
X44 a_1239_497# I VSS VPW nfet_05v0 ad=0.4161p pd=1.905u as=0.4224p ps=1.94u w=0.82u l=0.6u
X45 ZN a_489_68# VSS VPW nfet_05v0 ad=0.2132p pd=1.34u as=0.2132p ps=1.34u w=0.82u l=0.6u
X46 VDD a_1239_497# a_512_497# VNW pfet_05v0 ad=0.3953p pd=1.85u as=0.3658p ps=1.8u w=1.18u l=0.5u
X47 a_489_68# a_1239_497# VSS VPW nfet_05v0 ad=0.2132p pd=1.34u as=0.2132p ps=1.34u w=0.82u l=0.6u
X48 VSS a_489_68# ZN VPW nfet_05v0 ad=0.2132p pd=1.34u as=0.2132p ps=1.34u w=0.82u l=0.6u
X49 ZN a_489_68# VSS VPW nfet_05v0 ad=0.2132p pd=1.34u as=0.2132p ps=1.34u w=0.82u l=0.6u
X50 VDD I a_1239_497# VNW pfet_05v0 ad=0.60915p pd=2.315u as=0.58035p ps=2.155u w=1.095u l=0.5u
X51 VSS a_489_68# ZN VPW nfet_05v0 ad=0.2132p pd=1.34u as=0.2132p ps=1.34u w=0.82u l=0.6u
X52 ZN a_489_68# VSS VPW nfet_05v0 ad=0.2132p pd=1.34u as=0.2132p ps=1.34u w=0.82u l=0.6u
X53 VDD EN a_57_68# VNW pfet_05v0 ad=0.2847p pd=1.615u as=0.4818p ps=3.07u w=1.095u l=0.5u
X54 VDD a_512_497# ZN VNW pfet_05v0 ad=0.3658p pd=1.8u as=0.3658p ps=1.8u w=1.18u l=0.5u
X55 VSS a_1239_497# a_489_68# VPW nfet_05v0 ad=0.2132p pd=1.34u as=0.2132p ps=1.34u w=0.82u l=0.6u
X56 VDD a_1239_497# a_512_497# VNW pfet_05v0 ad=0.3658p pd=1.8u as=0.3658p ps=1.8u w=1.18u l=0.5u
X57 VSS a_489_68# ZN VPW nfet_05v0 ad=0.2132p pd=1.34u as=0.2132p ps=1.34u w=0.82u l=0.6u
X58 ZN a_512_497# VDD VNW pfet_05v0 ad=0.3658p pd=1.8u as=0.3658p ps=1.8u w=1.18u l=0.5u
X59 a_512_497# EN VDD VNW pfet_05v0 ad=0.2847p pd=1.615u as=0.2847p ps=1.615u w=1.095u l=0.5u
X60 VDD a_1239_497# a_512_497# VNW pfet_05v0 ad=0.3658p pd=1.8u as=0.3658p ps=1.8u w=1.18u l=0.5u
X61 VSS a_489_68# ZN VPW nfet_05v0 ad=0.2132p pd=1.34u as=0.2132p ps=1.34u w=0.82u l=0.6u
C0 a_512_497# VNW 2.47338f
C1 a_512_497# VDD 2.32441f
C2 a_512_497# a_489_68# 2.29583f
C3 a_512_497# ZN 2.50159f
C4 a_512_497# a_1239_497# 2.22528f
C5 VSS a_489_68# 2.3436f
C6 VSS VPW 2.29093f
C7 VNW VPW 12.3464f
C8 a_489_68# VPW 2.58634f
.ends

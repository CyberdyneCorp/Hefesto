* NGSPICE file created from gf180mcu_fd_sc_mcu7t5v0__dlyc_1.ext - technology: gf180mcuD

.subckt gf180mcu_fd_sc_mcu7t5v0__dlyc_1 I Z VDD VNW VPW VSS
X0 a_666_644# a_42_68# a_498_644# VNW pfet_05v0 ad=0.3852p pd=2.86u as=61.19999f ps=0.7u w=0.36u l=0.5u
X1 VSS I a_42_68# VPW nfet_05v0 ad=93.59999f pd=0.88u as=0.333p ps=2.57u w=0.36u l=0.6u
X2 a_1702_68# a_870_562# a_1554_644# VNW pfet_05v0 ad=0.3852p pd=2.86u as=61.19999f ps=0.7u w=0.36u l=0.5u
X3 Z a_1926_68# VDD VNW pfet_05v0 ad=0.5368p pd=3.32u as=0.379p ps=2.37u w=1.22u l=0.5u
X4 a_498_644# a_42_68# VDD VNW pfet_05v0 ad=61.19999f pd=0.7u as=0.1116p ps=0.98u w=0.36u l=0.5u
X5 a_1554_644# a_870_562# VDD VNW pfet_05v0 ad=61.19999f pd=0.7u as=0.1656p ps=1.28u w=0.36u l=0.5u
X6 a_1102_644# a_666_644# a_870_562# VNW pfet_05v0 ad=61.19999f pd=0.7u as=0.3852p ps=2.86u w=0.36u l=0.5u
X7 VDD I a_42_68# VNW pfet_05v0 ad=0.1116p pd=0.98u as=0.3852p ps=2.86u w=0.36u l=0.5u
X8 a_1534_68# a_870_562# VSS VPW nfet_05v0 ad=43.2f pd=0.6u as=93.59999f ps=0.88u w=0.36u l=0.6u
X9 a_1702_68# a_870_562# a_1534_68# VPW nfet_05v0 ad=0.369p pd=2.77u as=43.2f ps=0.6u w=0.36u l=0.6u
X10 Z a_1926_68# VSS VPW nfet_05v0 ad=0.3608p pd=2.52u as=0.28262p ps=1.87u w=0.82u l=0.6u
X11 VDD a_1702_68# a_2158_622# VNW pfet_05v0 ad=0.379p pd=2.37u as=61.19999f ps=0.7u w=0.36u l=0.5u
X12 a_518_68# a_42_68# VSS VPW nfet_05v0 ad=43.2f pd=0.6u as=93.59999f ps=0.88u w=0.36u l=0.6u
X13 a_666_644# a_42_68# a_518_68# VPW nfet_05v0 ad=0.369p pd=2.77u as=43.2f ps=0.6u w=0.36u l=0.6u
X14 a_1142_68# a_666_644# a_870_562# VPW nfet_05v0 ad=43.2f pd=0.6u as=0.369p ps=2.77u w=0.36u l=0.6u
X15 a_2158_622# a_1702_68# a_1926_68# VNW pfet_05v0 ad=61.19999f pd=0.7u as=0.3456p ps=2.64u w=0.36u l=0.5u
X16 a_2178_68# a_1702_68# a_1926_68# VPW nfet_05v0 ad=43.8f pd=0.605u as=0.3705p ps=2.77u w=0.365u l=0.6u
X17 VSS a_666_644# a_1142_68# VPW nfet_05v0 ad=93.59999f pd=0.88u as=43.2f ps=0.6u w=0.36u l=0.6u
X18 VSS a_1702_68# a_2178_68# VPW nfet_05v0 ad=0.28262p pd=1.87u as=43.8f ps=0.605u w=0.365u l=0.6u
X19 VDD a_666_644# a_1102_644# VNW pfet_05v0 ad=0.1656p pd=1.28u as=61.19999f ps=0.7u w=0.36u l=0.5u
C0 VNW VPW 4.61849f
.ends

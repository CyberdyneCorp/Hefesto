* NGSPICE file created from gf180mcu_fd_sc_mcu7t5v0__dffsnq_4.ext - technology: gf180mcuD

.subckt gf180mcu_fd_sc_mcu7t5v0__dffsnq_4 D SETN CLK Q VDD VNW VPW VSS
X0 VSS CLK a_36_151# VPW nfet_05v0 ad=0.1053p pd=0.925u as=0.1782p ps=1.69u w=0.405u l=0.6u
X1 Q a_3129_107# VDD VNW pfet_05v0 ad=0.4374p pd=1.935u as=0.3159p ps=1.735u w=1.215u l=0.5u
X2 a_1353_112# SETN a_1697_156# VPW nfet_05v0 ad=0.1989p pd=1.465u as=86.39999f ps=0.84u w=0.36u l=0.6u
X3 a_836_156# D VDD VNW pfet_05v0 ad=0.1313p pd=1.025u as=0.22725p ps=1.91u w=0.505u l=0.5u
X4 VDD a_3129_107# Q VNW pfet_05v0 ad=0.5346p pd=3.31u as=0.4374p ps=1.935u w=1.215u l=0.5u
X5 VSS a_2225_156# a_3129_107# VPW nfet_05v0 ad=0.2445p pd=1.415u as=0.2119p ps=1.335u w=0.815u l=0.6u
X6 a_1040_527# a_36_151# a_836_156# VPW nfet_05v0 ad=93.59999f pd=0.88u as=93.59999f ps=0.88u w=0.36u l=0.6u
X7 VSS a_3129_107# Q VPW nfet_05v0 ad=0.3586p pd=2.51u as=0.2119p ps=1.335u w=0.815u l=0.6u
X8 a_1040_527# a_448_472# a_836_156# VNW pfet_05v0 ad=0.19315p pd=1.27u as=0.1313p ps=1.025u w=0.505u l=0.5u
X9 a_2225_156# a_36_151# a_1353_112# VNW pfet_05v0 ad=0.1079p pd=0.935u as=0.27805p ps=2.17u w=0.415u l=0.5u
X10 VSS a_3129_107# Q VPW nfet_05v0 ad=0.2119p pd=1.335u as=0.2119p ps=1.335u w=0.815u l=0.6u
X11 VSS a_1353_112# a_1284_156# VPW nfet_05v0 ad=93.59999f pd=0.88u as=62.1f ps=0.705u w=0.36u l=0.6u
X12 a_2225_156# a_448_472# a_1353_112# VPW nfet_05v0 ad=93.59999f pd=0.88u as=0.1989p ps=1.465u w=0.36u l=0.6u
X13 Q a_3129_107# VSS VPW nfet_05v0 ad=0.2119p pd=1.335u as=0.2445p ps=1.415u w=0.815u l=0.6u
X14 VDD CLK a_36_151# VNW pfet_05v0 ad=0.2249p pd=1.385u as=0.3806p ps=2.61u w=0.865u l=0.5u
X15 a_2449_156# a_448_472# a_2225_156# VNW pfet_05v0 ad=0.1826p pd=1.71u as=0.1079p ps=0.935u w=0.415u l=0.5u
X16 VDD a_3129_107# a_2449_156# VNW pfet_05v0 ad=0.39635p pd=1.895u as=0.2028p ps=1.3u w=0.78u l=0.5u
X17 a_448_472# a_36_151# VDD VNW pfet_05v0 ad=0.3806p pd=2.61u as=0.2249p ps=1.385u w=0.865u l=0.5u
X18 a_2449_156# SETN VDD VNW pfet_05v0 ad=0.2028p pd=1.3u as=0.3432p ps=2.44u w=0.78u l=0.5u
X19 VSS a_3129_107# a_3081_151# VPW nfet_05v0 ad=0.24005p pd=1.555u as=48.6f ps=0.645u w=0.405u l=0.6u
X20 a_836_156# D VSS VPW nfet_05v0 ad=93.59999f pd=0.88u as=0.1584p ps=1.6u w=0.36u l=0.6u
X21 a_448_472# a_36_151# VSS VPW nfet_05v0 ad=0.1782p pd=1.69u as=0.1053p ps=0.925u w=0.405u l=0.6u
X22 a_1353_112# a_1040_527# VDD VNW pfet_05v0 ad=0.1521p pd=1.105u as=0.3975p ps=2.185u w=0.585u l=0.5u
X23 VDD SETN a_1353_112# VNW pfet_05v0 ad=0.4149p pd=2.65u as=0.1521p ps=1.105u w=0.585u l=0.5u
X24 a_1284_156# a_448_472# a_1040_527# VPW nfet_05v0 ad=62.1f pd=0.705u as=93.59999f ps=0.88u w=0.36u l=0.6u
X25 Q a_3129_107# VDD VNW pfet_05v0 ad=0.4374p pd=1.935u as=0.40125p ps=1.915u w=1.215u l=0.5u
X26 VDD a_1353_112# a_1293_527# VNW pfet_05v0 ad=0.3975p pd=2.185u as=0.101p ps=0.905u w=0.505u l=0.5u
X27 a_3129_107# a_2225_156# VDD VNW pfet_05v0 ad=0.2743p pd=1.575u as=0.39635p ps=1.895u w=1.055u l=0.5u
X28 a_2449_156# a_36_151# a_2225_156# VPW nfet_05v0 ad=0.2898p pd=2.33u as=93.59999f ps=0.88u w=0.36u l=0.6u
X29 a_1293_527# a_36_151# a_1040_527# VNW pfet_05v0 ad=0.101p pd=0.905u as=0.19315p ps=1.27u w=0.505u l=0.5u
X30 a_1697_156# a_1040_527# VSS VPW nfet_05v0 ad=86.39999f pd=0.84u as=93.59999f ps=0.88u w=0.36u l=0.6u
X31 a_3129_107# a_2225_156# VSS VPW nfet_05v0 ad=0.2119p pd=1.335u as=0.24005p ps=1.555u w=0.815u l=0.6u
X32 Q a_3129_107# VSS VPW nfet_05v0 ad=0.2119p pd=1.335u as=0.2119p ps=1.335u w=0.815u l=0.6u
X33 VDD a_3129_107# Q VNW pfet_05v0 ad=0.3159p pd=1.735u as=0.4374p ps=1.935u w=1.215u l=0.5u
X34 a_3081_151# SETN a_2449_156# VPW nfet_05v0 ad=48.6f pd=0.645u as=0.3123p ps=2.38u w=0.405u l=0.6u
X35 VDD a_2225_156# a_3129_107# VNW pfet_05v0 ad=0.40125p pd=1.915u as=0.2743p ps=1.575u w=1.055u l=0.5u
C0 VNW VPW 7.6609f
.ends

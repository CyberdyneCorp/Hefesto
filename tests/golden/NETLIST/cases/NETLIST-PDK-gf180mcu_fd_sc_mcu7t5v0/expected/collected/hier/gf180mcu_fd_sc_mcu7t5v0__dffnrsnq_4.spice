* NGSPICE file created from gf180mcu_fd_sc_mcu7t5v0__dffnrsnq_4.ext - technology: gf180mcuD

.subckt gf180mcu_fd_sc_mcu7t5v0__dffnrsnq_4 D RN SETN CLKN Q VDD VNW VPW VSS
X0 a_1308_156# a_36_151# a_1044_504# VPW nfet_05v0 ad=45.6f pd=0.62u as=98.8f ps=0.9u w=0.38u l=0.6u
X1 a_2978_204# a_36_151# a_1356_112# VPW nfet_05v0 ad=93.59999f pd=0.88u as=93.59999f ps=0.88u w=0.36u l=0.6u
X2 VDD a_3811_112# Q VNW pfet_05v0 ad=0.5346p pd=3.31u as=0.3159p ps=1.735u w=1.215u l=0.5u
X3 VSS CLKN a_36_151# VPW nfet_05v0 ad=0.1053p pd=0.925u as=0.1782p ps=1.69u w=0.405u l=0.6u
X4 a_3811_112# a_2978_204# a_4155_156# VPW nfet_05v0 ad=0.1584p pd=1.6u as=43.2f ps=0.6u w=0.36u l=0.6u
X5 a_3763_156# SETN a_3202_204# VPW nfet_05v0 ad=43.2f pd=0.6u as=0.1584p ps=1.6u w=0.36u l=0.6u
X6 VDD a_1044_504# a_1356_112# VNW pfet_05v0 ad=0.49655p pd=2.13u as=0.3542p ps=2.49u w=0.805u l=0.5u
X7 a_2544_204# a_1044_504# VSS VPW nfet_05v0 ad=81f pd=0.81u as=0.54155p ps=2.84u w=0.36u l=0.6u
X8 a_1044_504# a_448_487# a_840_504# VPW nfet_05v0 ad=98.8f pd=0.9u as=98.8f ps=0.9u w=0.38u l=0.6u
X9 a_3202_204# a_448_487# a_2978_204# VPW nfet_05v0 ad=0.1638p pd=1.63u as=93.59999f ps=0.88u w=0.36u l=0.6u
X10 a_4155_156# RN VSS VPW nfet_05v0 ad=43.2f pd=0.6u as=93.59999f ps=0.88u w=0.36u l=0.6u
X11 a_840_504# D VDD VNW pfet_05v0 ad=0.1066p pd=0.93u as=0.402p ps=2.87u w=0.41u l=0.5u
X12 a_1356_112# SETN a_2544_204# VPW nfet_05v0 ad=93.59999f pd=0.88u as=81f ps=0.81u w=0.36u l=0.6u
X13 a_1044_504# a_36_151# a_840_504# VNW pfet_05v0 ad=0.1066p pd=0.93u as=0.1066p ps=0.93u w=0.41u l=0.5u
X14 VDD a_1356_112# a_1248_504# VNW pfet_05v0 ad=1.04445p pd=3.58u as=0.1107p ps=0.95u w=0.41u l=0.5u
X15 a_3811_112# RN VDD VNW pfet_05v0 ad=0.2275p pd=1.395u as=0.2275p ps=1.395u w=0.875u l=0.5u
X16 a_3202_204# SETN VDD VNW pfet_05v0 ad=0.2275p pd=1.395u as=0.385p ps=2.63u w=0.875u l=0.5u
X17 VDD a_2978_204# a_3811_112# VNW pfet_05v0 ad=0.385p pd=2.63u as=0.2275p ps=1.395u w=0.875u l=0.5u
X18 Q a_3811_112# VSS VPW nfet_05v0 ad=0.2119p pd=1.335u as=0.2119p ps=1.335u w=0.815u l=0.6u
X19 VDD a_3811_112# a_3202_204# VNW pfet_05v0 ad=0.2275p pd=1.395u as=0.2275p ps=1.395u w=0.875u l=0.5u
X20 a_448_487# a_36_151# VSS VPW nfet_05v0 ad=0.1782p pd=1.69u as=0.1053p ps=0.925u w=0.405u l=0.6u
X21 VSS a_3811_112# Q VPW nfet_05v0 ad=0.2119p pd=1.335u as=0.2119p ps=1.335u w=0.815u l=0.6u
X22 a_1248_504# a_448_487# a_1044_504# VNW pfet_05v0 ad=0.1107p pd=0.95u as=0.1066p ps=0.93u w=0.41u l=0.5u
X23 Q a_3811_112# VDD VNW pfet_05v0 ad=0.3159p pd=1.735u as=0.5346p ps=3.31u w=1.215u l=0.5u
X24 a_840_504# D VSS VPW nfet_05v0 ad=98.8f pd=0.9u as=0.1672p ps=1.64u w=0.38u l=0.6u
X25 VDD CLKN a_36_151# VNW pfet_05v0 ad=0.2249p pd=1.385u as=0.3806p ps=2.61u w=0.865u l=0.5u
X26 a_2978_204# a_448_487# a_1356_112# VNW pfet_05v0 ad=0.1456p pd=1.08u as=0.1456p ps=1.08u w=0.56u l=0.5u
X27 VDD a_3811_112# Q VNW pfet_05v0 ad=0.3159p pd=1.735u as=0.3159p ps=1.735u w=1.215u l=0.5u
X28 a_1476_156# a_1356_112# a_1308_156# VPW nfet_05v0 ad=0.3914p pd=2.44u as=45.6f ps=0.62u w=0.38u l=0.6u
X29 VSS a_3811_112# Q VPW nfet_05v0 ad=0.3586p pd=2.51u as=0.2119p ps=1.335u w=0.815u l=0.6u
X30 a_3202_204# a_36_151# a_2978_204# VNW pfet_05v0 ad=0.2464p pd=2u as=0.1456p ps=1.08u w=0.56u l=0.5u
X31 a_448_487# a_36_151# VDD VNW pfet_05v0 ad=0.3806p pd=2.61u as=0.2249p ps=1.385u w=0.865u l=0.5u
X32 a_1356_112# SETN VDD VNW pfet_05v0 ad=0.1456p pd=1.08u as=0.49655p ps=2.13u w=0.56u l=0.5u
X33 VSS RN a_1476_156# VPW nfet_05v0 ad=0.54155p pd=2.84u as=0.3914p ps=2.44u w=0.38u l=0.6u
X34 a_1248_504# RN VDD VNW pfet_05v0 ad=0.3542p pd=2.49u as=1.04445p ps=3.58u w=0.805u l=0.5u
X35 Q a_3811_112# VDD VNW pfet_05v0 ad=0.3159p pd=1.735u as=0.3159p ps=1.735u w=1.215u l=0.5u
X36 Q a_3811_112# VSS VPW nfet_05v0 ad=0.2119p pd=1.335u as=0.3586p ps=2.51u w=0.815u l=0.6u
X37 VSS a_3811_112# a_3763_156# VPW nfet_05v0 ad=93.59999f pd=0.88u as=43.2f ps=0.6u w=0.36u l=0.6u
C0 VNW VPW 8.60728f
.ends

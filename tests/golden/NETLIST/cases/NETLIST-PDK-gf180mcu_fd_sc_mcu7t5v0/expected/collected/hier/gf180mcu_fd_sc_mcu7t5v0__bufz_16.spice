* NGSPICE file created from gf180mcu_fd_sc_mcu7t5v0__bufz_16.ext - technology: gf180mcuD

.subckt gf180mcu_fd_sc_mcu7t5v0__bufz_16 EN I Z VDD VNW VPW VSS
X0 a_476_527# I VDD VNW pfet_05v0 ad=0.299p pd=1.67u as=0.299p ps=1.67u w=1.15u l=0.5u
X1 Z a_468_69# VSS VPW nfet_05v0 ad=0.2132p pd=1.34u as=0.2132p ps=1.34u w=0.82u l=0.6u
X2 VDD a_476_527# Z VNW pfet_05v0 ad=0.3055p pd=1.695u as=0.3055p ps=1.695u w=1.175u l=0.5u
X3 Z a_476_527# VDD VNW pfet_05v0 ad=0.3055p pd=1.695u as=0.3055p ps=1.695u w=1.175u l=0.5u
X4 Z a_468_69# VSS VPW nfet_05v0 ad=0.2132p pd=1.34u as=0.2132p ps=1.34u w=0.82u l=0.6u
X5 Z a_476_527# VDD VNW pfet_05v0 ad=0.3055p pd=1.695u as=0.3055p ps=1.695u w=1.175u l=0.5u
X6 VSS I a_468_69# VPW nfet_05v0 ad=0.2132p pd=1.34u as=0.2132p ps=1.34u w=0.82u l=0.6u
X7 VDD I a_476_527# VNW pfet_05v0 ad=0.299p pd=1.67u as=0.299p ps=1.67u w=1.15u l=0.5u
X8 VDD EN a_36_69# VNW pfet_05v0 ad=0.2392p pd=1.44u as=0.4048p ps=2.72u w=0.92u l=0.5u
X9 VDD a_476_527# Z VNW pfet_05v0 ad=0.3055p pd=1.695u as=0.3055p ps=1.695u w=1.175u l=0.5u
X10 Z a_468_69# VSS VPW nfet_05v0 ad=0.2132p pd=1.34u as=0.2132p ps=1.34u w=0.82u l=0.6u
X11 a_476_527# I VDD VNW pfet_05v0 ad=0.4715p pd=1.97u as=0.299p ps=1.67u w=1.15u l=0.5u
X12 VSS I a_468_69# VPW nfet_05v0 ad=0.2132p pd=1.34u as=0.2132p ps=1.34u w=0.82u l=0.6u
X13 VSS I a_468_69# VPW nfet_05v0 ad=0.2132p pd=1.34u as=0.2132p ps=1.34u w=0.82u l=0.6u
X14 VDD a_476_527# Z VNW pfet_05v0 ad=0.3055p pd=1.695u as=0.3055p ps=1.695u w=1.175u l=0.5u
X15 a_468_69# a_36_69# VSS VPW nfet_05v0 ad=0.2119p pd=1.335u as=0.2119p ps=1.335u w=0.815u l=0.6u
X16 Z a_476_527# VDD VNW pfet_05v0 ad=0.3055p pd=1.695u as=0.3055p ps=1.695u w=1.175u l=0.5u
X17 a_476_527# EN VDD VNW pfet_05v0 ad=0.4232p pd=1.84u as=0.2392p ps=1.44u w=0.92u l=0.5u
X18 VDD I a_476_527# VNW pfet_05v0 ad=0.3055p pd=1.695u as=0.4075p ps=1.875u w=1.175u l=0.5u
X19 Z a_476_527# VDD VNW pfet_05v0 ad=0.3055p pd=1.695u as=0.3055p ps=1.695u w=1.175u l=0.5u
X20 VSS I a_468_69# VPW nfet_05v0 ad=0.2132p pd=1.34u as=0.2132p ps=1.34u w=0.82u l=0.6u
X21 Z a_476_527# VDD VNW pfet_05v0 ad=0.3055p pd=1.695u as=0.3055p ps=1.695u w=1.175u l=0.5u
X22 VDD a_476_527# Z VNW pfet_05v0 ad=0.517p pd=3.23u as=0.3055p ps=1.695u w=1.175u l=0.5u
X23 a_468_69# I VSS VPW nfet_05v0 ad=0.2132p pd=1.34u as=0.2132p ps=1.34u w=0.82u l=0.6u
X24 VSS a_468_69# Z VPW nfet_05v0 ad=0.2132p pd=1.34u as=0.2132p ps=1.34u w=0.82u l=0.6u
X25 VDD a_476_527# Z VNW pfet_05v0 ad=0.3055p pd=1.695u as=0.3055p ps=1.695u w=1.175u l=0.5u
X26 a_468_69# I VSS VPW nfet_05v0 ad=0.2132p pd=1.34u as=0.2132p ps=1.34u w=0.82u l=0.6u
X27 VSS a_468_69# Z VPW nfet_05v0 ad=0.2132p pd=1.34u as=0.2132p ps=1.34u w=0.82u l=0.6u
X28 Z a_476_527# VDD VNW pfet_05v0 ad=0.3055p pd=1.695u as=0.3055p ps=1.695u w=1.175u l=0.5u
X29 a_476_527# EN a_468_69# VPW nfet_05v0 ad=0.6369p pd=3.5u as=0.2119p ps=1.335u w=0.815u l=0.6u
X30 Z a_476_527# VDD VNW pfet_05v0 ad=0.3055p pd=1.695u as=0.3055p ps=1.695u w=1.175u l=0.5u
X31 a_468_69# I VSS VPW nfet_05v0 ad=0.2132p pd=1.34u as=0.5988p ps=3.28u w=0.82u l=0.6u
X32 VSS EN a_36_69# VPW nfet_05v0 ad=0.2119p pd=1.335u as=0.3586p ps=2.51u w=0.815u l=0.6u
X33 VSS a_468_69# Z VPW nfet_05v0 ad=0.3608p pd=2.52u as=0.2132p ps=1.34u w=0.82u l=0.6u
X34 a_468_69# a_36_69# a_476_527# VNW pfet_05v0 ad=0.4048p pd=2.72u as=0.4232p ps=1.84u w=0.92u l=0.5u
X35 Z a_468_69# VSS VPW nfet_05v0 ad=0.2132p pd=1.34u as=0.2132p ps=1.34u w=0.82u l=0.6u
X36 VDD a_476_527# Z VNW pfet_05v0 ad=0.3055p pd=1.695u as=0.3055p ps=1.695u w=1.175u l=0.5u
X37 Z a_468_69# VSS VPW nfet_05v0 ad=0.2132p pd=1.34u as=0.2132p ps=1.34u w=0.82u l=0.6u
X38 Z a_468_69# VSS VPW nfet_05v0 ad=0.2132p pd=1.34u as=0.2132p ps=1.34u w=0.82u l=0.6u
X39 VSS a_468_69# Z VPW nfet_05v0 ad=0.2132p pd=1.34u as=0.2132p ps=1.34u w=0.82u l=0.6u
X40 VSS a_468_69# Z VPW nfet_05v0 ad=0.2132p pd=1.34u as=0.2132p ps=1.34u w=0.82u l=0.6u
X41 Z a_468_69# VSS VPW nfet_05v0 ad=0.2132p pd=1.34u as=0.2132p ps=1.34u w=0.82u l=0.6u
X42 VDD I a_476_527# VNW pfet_05v0 ad=0.299p pd=1.67u as=0.4715p ps=1.97u w=1.15u l=0.5u
X43 VDD a_476_527# Z VNW pfet_05v0 ad=0.3055p pd=1.695u as=0.3055p ps=1.695u w=1.175u l=0.5u
X44 a_476_527# I VDD VNW pfet_05v0 ad=0.299p pd=1.67u as=0.506p ps=3.18u w=1.15u l=0.5u
X45 VSS a_468_69# Z VPW nfet_05v0 ad=0.2132p pd=1.34u as=0.2132p ps=1.34u w=0.82u l=0.6u
X46 VSS a_468_69# Z VPW nfet_05v0 ad=0.2132p pd=1.34u as=0.2132p ps=1.34u w=0.82u l=0.6u
X47 a_476_527# I VDD VNW pfet_05v0 ad=0.4075p pd=1.875u as=0.299p ps=1.67u w=1.15u l=0.5u
X48 VDD I a_476_527# VNW pfet_05v0 ad=0.299p pd=1.67u as=0.299p ps=1.67u w=1.15u l=0.5u
X49 Z a_476_527# VDD VNW pfet_05v0 ad=0.3055p pd=1.695u as=0.3055p ps=1.695u w=1.175u l=0.5u
X50 Z a_468_69# VSS VPW nfet_05v0 ad=0.2132p pd=1.34u as=0.2132p ps=1.34u w=0.82u l=0.6u
X51 VDD a_476_527# Z VNW pfet_05v0 ad=0.3055p pd=1.695u as=0.3055p ps=1.695u w=1.175u l=0.5u
X52 a_468_69# I VSS VPW nfet_05v0 ad=0.2132p pd=1.34u as=0.2132p ps=1.34u w=0.82u l=0.6u
X53 VSS a_468_69# Z VPW nfet_05v0 ad=0.2132p pd=1.34u as=0.2132p ps=1.34u w=0.82u l=0.6u
C0 a_468_69# Z 2.00974f
C1 a_476_527# Z 2.03979f
C2 a_468_69# a_476_527# 2.6494f
C3 a_476_527# VNW 2.2431f
C4 VNW VPW 10.3004f
C5 a_468_69# VPW 2.61627f
.ends

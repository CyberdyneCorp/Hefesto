* NGSPICE file created from gf180mcu_fd_sc_mcu7t5v0__bufz_8.ext - technology: gf180mcuD

.subckt gf180mcu_fd_sc_mcu7t5v0__bufz_8 EN I Z VDD VNW VPW VSS
X0 a_476_527# I VDD VNW pfet_05v0 ad=0.3055p pd=1.695u as=0.3055p ps=1.695u w=1.175u l=0.5u
X1 VDD a_476_527# Z VNW pfet_05v0 ad=0.3055p pd=1.695u as=0.3055p ps=1.695u w=1.175u l=0.5u
X2 Z a_468_68# VSS VPW nfet_05v0 ad=0.2132p pd=1.34u as=0.2132p ps=1.34u w=0.82u l=0.6u
X3 VSS I a_468_68# VPW nfet_05v0 ad=0.2132p pd=1.34u as=0.2132p ps=1.34u w=0.82u l=0.6u
X4 VDD I a_476_527# VNW pfet_05v0 ad=0.3055p pd=1.695u as=0.3055p ps=1.695u w=1.175u l=0.5u
X5 a_476_527# EN a_468_68# VPW nfet_05v0 ad=0.6402p pd=3.51u as=0.2132p ps=1.34u w=0.82u l=0.6u
X6 VDD EN a_36_68# VNW pfet_05v0 ad=0.2457p pd=1.465u as=0.4158p ps=2.77u w=0.945u l=0.5u
X7 Z a_476_527# VDD VNW pfet_05v0 ad=0.3055p pd=1.695u as=0.3055p ps=1.695u w=1.175u l=0.5u
X8 Z a_476_527# VDD VNW pfet_05v0 ad=0.3055p pd=1.695u as=0.3055p ps=1.695u w=1.175u l=0.5u
X9 VSS EN a_36_68# VPW nfet_05v0 ad=0.2132p pd=1.34u as=0.3608p ps=2.52u w=0.82u l=0.6u
X10 VSS I a_468_68# VPW nfet_05v0 ad=0.2132p pd=1.34u as=0.2132p ps=1.34u w=0.82u l=0.6u
X11 VSS a_468_68# Z VPW nfet_05v0 ad=0.2132p pd=1.34u as=0.2132p ps=1.34u w=0.82u l=0.6u
X12 VDD a_476_527# Z VNW pfet_05v0 ad=0.3055p pd=1.695u as=0.3055p ps=1.695u w=1.175u l=0.5u
X13 a_476_527# EN VDD VNW pfet_05v0 ad=0.4347p pd=1.865u as=0.2457p ps=1.465u w=0.945u l=0.5u
X14 Z a_476_527# VDD VNW pfet_05v0 ad=0.3055p pd=1.695u as=0.3055p ps=1.695u w=1.175u l=0.5u
X15 VSS a_468_68# Z VPW nfet_05v0 ad=0.2132p pd=1.34u as=0.2132p ps=1.34u w=0.82u l=0.6u
X16 Z a_476_527# VDD VNW pfet_05v0 ad=0.3055p pd=1.695u as=0.3055p ps=1.695u w=1.175u l=0.5u
X17 Z a_468_68# VSS VPW nfet_05v0 ad=0.2132p pd=1.34u as=0.2132p ps=1.34u w=0.82u l=0.6u
X18 VDD a_476_527# Z VNW pfet_05v0 ad=0.517p pd=3.23u as=0.3055p ps=1.695u w=1.175u l=0.5u
X19 a_468_68# I VSS VPW nfet_05v0 ad=0.2132p pd=1.34u as=0.2132p ps=1.34u w=0.82u l=0.6u
X20 VSS a_468_68# Z VPW nfet_05v0 ad=0.2132p pd=1.34u as=0.2132p ps=1.34u w=0.82u l=0.6u
X21 VDD a_476_527# Z VNW pfet_05v0 ad=0.3055p pd=1.695u as=0.3055p ps=1.695u w=1.175u l=0.5u
X22 a_468_68# I VSS VPW nfet_05v0 ad=0.2132p pd=1.34u as=0.5988p ps=3.28u w=0.82u l=0.6u
X23 a_468_68# a_36_68# a_476_527# VNW pfet_05v0 ad=0.4158p pd=2.77u as=0.4347p ps=1.865u w=0.945u l=0.5u
X24 VSS a_468_68# Z VPW nfet_05v0 ad=0.3608p pd=2.52u as=0.2132p ps=1.34u w=0.82u l=0.6u
X25 a_476_527# I VDD VNW pfet_05v0 ad=0.3055p pd=1.695u as=0.517p ps=3.23u w=1.175u l=0.5u
X26 a_468_68# a_36_68# VSS VPW nfet_05v0 ad=0.2132p pd=1.34u as=0.2132p ps=1.34u w=0.82u l=0.6u
X27 VDD I a_476_527# VNW pfet_05v0 ad=0.3055p pd=1.695u as=0.3055p ps=1.695u w=1.175u l=0.5u
X28 Z a_468_68# VSS VPW nfet_05v0 ad=0.2132p pd=1.34u as=0.2132p ps=1.34u w=0.82u l=0.6u
X29 Z a_468_68# VSS VPW nfet_05v0 ad=0.2132p pd=1.34u as=0.2132p ps=1.34u w=0.82u l=0.6u
C0 VNW VPW 6.1242f
.ends

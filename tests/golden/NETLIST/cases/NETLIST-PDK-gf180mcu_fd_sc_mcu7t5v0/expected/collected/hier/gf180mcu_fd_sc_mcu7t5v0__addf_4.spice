* NGSPICE file created from gf180mcu_fd_sc_mcu7t5v0__addf_4.ext - technology: gf180mcuD

.subckt gf180mcu_fd_sc_mcu7t5v0__addf_4 A B CI CO S VDD VNW VPW VSS
X0 S a_140_24# VSS VPW nfet_05v0 ad=0.2119p pd=1.335u as=0.3586p ps=2.51u w=0.815u l=0.6u
X1 VSS A a_3696_156# VPW nfet_05v0 ad=0.2363p pd=1.555u as=45.6f ps=0.62u w=0.38u l=0.6u
X2 VDD A a_1760_496# VNW pfet_05v0 ad=0.3456p pd=1.78u as=0.2046p ps=1.28u w=0.66u l=0.5u
X3 a_2728_156# A VSS VPW nfet_05v0 ad=98.8f pd=0.9u as=0.2112p ps=1.5u w=0.38u l=0.6u
X4 CO a_1640_112# VSS VPW nfet_05v0 ad=0.2119p pd=1.335u as=0.2119p ps=1.335u w=0.815u l=0.6u
X5 a_1368_496# B a_1200_496# VNW pfet_05v0 ad=0.1122p pd=1u as=0.1122p ps=1u w=0.66u l=0.5u
X6 VSS B a_2728_156# VPW nfet_05v0 ad=0.2112p pd=1.5u as=0.1672p ps=1.64u w=0.38u l=0.6u
X7 a_1760_156# a_1640_112# a_140_24# VPW nfet_05v0 ad=98.8f pd=0.9u as=98.8f ps=0.9u w=0.38u l=0.6u
X8 CO a_1640_112# VSS VPW nfet_05v0 ad=0.2119p pd=1.335u as=0.2363p ps=1.555u w=0.815u l=0.6u
X9 VDD A a_3676_472# VNW pfet_05v0 ad=0.44505p pd=2.055u as=0.1326p ps=1.12u w=0.78u l=0.5u
X10 a_2748_472# A VDD VNW pfet_05v0 ad=0.2418p pd=1.4u as=0.4032p ps=1.9u w=0.78u l=0.5u
X11 a_3696_156# B a_1640_112# VPW nfet_05v0 ad=45.6f pd=0.62u as=98.8f ps=0.9u w=0.38u l=0.6u
X12 a_3676_472# B a_1640_112# VNW pfet_05v0 ad=0.1326p pd=1.12u as=0.2418p ps=1.4u w=0.78u l=0.5u
X13 S a_140_24# VDD VNW pfet_05v0 ad=0.3942p pd=1.815u as=0.4818p ps=3.07u w=1.095u l=0.5u
X14 CO a_1640_112# VDD VNW pfet_05v0 ad=0.4374p pd=1.935u as=0.44505p ps=2.055u w=1.215u l=0.5u
X15 S a_140_24# VSS VPW nfet_05v0 ad=0.2119p pd=1.335u as=0.2119p ps=1.335u w=0.815u l=0.6u
X16 VDD a_140_24# S VNW pfet_05v0 ad=0.2847p pd=1.615u as=0.3942p ps=1.815u w=1.095u l=0.5u
X17 a_1760_496# a_1640_112# a_140_24# VNW pfet_05v0 ad=0.2046p pd=1.28u as=0.2046p ps=1.28u w=0.66u l=0.5u
X18 a_1200_496# A VDD VNW pfet_05v0 ad=0.1122p pd=1u as=0.3729p ps=1.935u w=0.66u l=0.5u
X19 a_1760_496# B VDD VNW pfet_05v0 ad=0.2442p pd=1.4u as=0.3456p ps=1.78u w=0.66u l=0.5u
X20 VDD a_1640_112# CO VNW pfet_05v0 ad=0.3159p pd=1.735u as=0.4374p ps=1.935u w=1.215u l=0.5u
X21 a_140_24# CI a_1368_156# VPW nfet_05v0 ad=98.8f pd=0.9u as=45.6f ps=0.62u w=0.38u l=0.6u
X22 VDD CI a_1760_496# VNW pfet_05v0 ad=0.2904p pd=2.2u as=0.2442p ps=1.4u w=0.66u l=0.5u
X23 S a_140_24# VDD VNW pfet_05v0 ad=0.3942p pd=1.815u as=0.2847p ps=1.615u w=1.095u l=0.5u
X24 CO a_1640_112# VDD VNW pfet_05v0 ad=0.4374p pd=1.935u as=0.3159p ps=1.735u w=1.215u l=0.5u
X25 VSS a_140_24# S VPW nfet_05v0 ad=0.2363p pd=1.555u as=0.2119p ps=1.335u w=0.815u l=0.6u
X26 a_1640_112# CI a_2728_156# VPW nfet_05v0 ad=98.8f pd=0.9u as=98.8f ps=0.9u w=0.38u l=0.6u
X27 a_1760_156# B VSS VPW nfet_05v0 ad=0.1216p pd=1.02u as=0.2112p ps=1.5u w=0.38u l=0.6u
X28 VSS CI a_1760_156# VPW nfet_05v0 ad=0.2128p pd=1.88u as=0.1216p ps=1.02u w=0.38u l=0.6u
X29 VDD B a_2748_472# VNW pfet_05v0 ad=0.4032p pd=1.9u as=0.3432p ps=2.44u w=0.78u l=0.5u
X30 VSS a_140_24# S VPW nfet_05v0 ad=0.2119p pd=1.335u as=0.2119p ps=1.335u w=0.815u l=0.6u
X31 a_1368_156# B a_1200_156# VPW nfet_05v0 ad=45.6f pd=0.62u as=45.6f ps=0.62u w=0.38u l=0.6u
X32 VSS A a_1760_156# VPW nfet_05v0 ad=0.2112p pd=1.5u as=98.8f ps=0.9u w=0.38u l=0.6u
X33 a_1640_112# CI a_2748_472# VNW pfet_05v0 ad=0.2418p pd=1.4u as=0.2418p ps=1.4u w=0.78u l=0.5u
X34 VSS a_1640_112# CO VPW nfet_05v0 ad=0.3586p pd=2.51u as=0.2119p ps=1.335u w=0.815u l=0.6u
X35 VSS a_1640_112# CO VPW nfet_05v0 ad=0.2119p pd=1.335u as=0.2119p ps=1.335u w=0.815u l=0.6u
X36 a_1200_156# A VSS VPW nfet_05v0 ad=45.6f pd=0.62u as=0.2363p ps=1.555u w=0.38u l=0.6u
X37 VDD a_140_24# S VNW pfet_05v0 ad=0.3729p pd=1.935u as=0.3942p ps=1.815u w=1.095u l=0.5u
X38 a_140_24# CI a_1368_496# VNW pfet_05v0 ad=0.2046p pd=1.28u as=0.1122p ps=1u w=0.66u l=0.5u
X39 VDD a_1640_112# CO VNW pfet_05v0 ad=0.5346p pd=3.31u as=0.4374p ps=1.935u w=1.215u l=0.5u
C0 VNW VPW 7.9254f
.ends

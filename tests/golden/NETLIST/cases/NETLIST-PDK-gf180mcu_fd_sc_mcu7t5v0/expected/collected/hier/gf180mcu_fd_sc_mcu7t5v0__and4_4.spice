* NGSPICE file created from gf180mcu_fd_sc_mcu7t5v0__and4_4.ext - technology: gf180mcuD

.subckt gf180mcu_fd_sc_mcu7t5v0__and4_4 A1 A2 A3 A4 Z VDD VNW VPW VSS
X0 VDD A2 a_227_494# VNW pfet_05v0 ad=0.2886p pd=1.63u as=0.2886p ps=1.63u w=1.11u l=0.5u
X1 a_247_68# A4 VSS VPW nfet_05v0 ad=0.1032p pd=0.965u as=0.2838p ps=2.17u w=0.645u l=0.6u
X2 a_227_494# A3 VDD VNW pfet_05v0 ad=0.2886p pd=1.63u as=0.2886p ps=1.63u w=1.11u l=0.5u
X3 VDD A4 a_227_494# VNW pfet_05v0 ad=0.4105p pd=1.92u as=0.2886p ps=1.63u w=1.11u l=0.5u
X4 a_1451_68# A3 a_1247_68# VPW nfet_05v0 ad=0.13545p pd=1.065u as=0.13545p ps=1.065u w=0.645u l=0.6u
X5 Z a_227_494# VSS VPW nfet_05v0 ad=0.1677p pd=1.165u as=0.1677p ps=1.165u w=0.645u l=0.6u
X6 a_1247_68# A2 a_1063_68# VPW nfet_05v0 ad=0.13545p pd=1.065u as=0.1032p ps=0.965u w=0.645u l=0.6u
X7 a_227_494# A1 a_635_68# VPW nfet_05v0 ad=0.19832p pd=1.26u as=0.1048p ps=0.97u w=0.645u l=0.6u
X8 a_227_494# A4 VDD VNW pfet_05v0 ad=0.2886p pd=1.63u as=0.4884p ps=3.1u w=1.11u l=0.5u
X9 Z a_227_494# VSS VPW nfet_05v0 ad=0.1677p pd=1.165u as=0.1677p ps=1.165u w=0.645u l=0.6u
X10 VDD A3 a_227_494# VNW pfet_05v0 ad=0.2886p pd=1.63u as=0.2886p ps=1.63u w=1.11u l=0.5u
X11 a_1063_68# A1 a_227_494# VPW nfet_05v0 ad=0.1032p pd=0.965u as=0.19832p ps=1.26u w=0.645u l=0.6u
X12 Z a_227_494# VDD VNW pfet_05v0 ad=0.3172p pd=1.74u as=0.4105p ps=1.92u w=1.22u l=0.5u
X13 a_431_68# A3 a_247_68# VPW nfet_05v0 ad=0.13545p pd=1.065u as=0.1032p ps=0.965u w=0.645u l=0.6u
X14 VSS a_227_494# Z VPW nfet_05v0 ad=0.1677p pd=1.165u as=0.1677p ps=1.165u w=0.645u l=0.6u
X15 a_227_494# A2 VDD VNW pfet_05v0 ad=0.2886p pd=1.63u as=0.2886p ps=1.63u w=1.11u l=0.5u
X16 VDD a_227_494# Z VNW pfet_05v0 ad=0.3172p pd=1.74u as=0.3172p ps=1.74u w=1.22u l=0.5u
X17 VSS A4 a_1451_68# VPW nfet_05v0 ad=0.1677p pd=1.165u as=0.13545p ps=1.065u w=0.645u l=0.6u
X18 Z a_227_494# VDD VNW pfet_05v0 ad=0.3172p pd=1.74u as=0.3172p ps=1.74u w=1.22u l=0.5u
X19 VSS a_227_494# Z VPW nfet_05v0 ad=0.2838p pd=2.17u as=0.1677p ps=1.165u w=0.645u l=0.6u
X20 VDD A1 a_227_494# VNW pfet_05v0 ad=0.2886p pd=1.63u as=0.2886p ps=1.63u w=1.11u l=0.5u
X21 a_227_494# A1 VDD VNW pfet_05v0 ad=0.2886p pd=1.63u as=0.2886p ps=1.63u w=1.11u l=0.5u
X22 VDD a_227_494# Z VNW pfet_05v0 ad=0.5368p pd=3.32u as=0.3172p ps=1.74u w=1.22u l=0.5u
X23 a_635_68# A2 a_431_68# VPW nfet_05v0 ad=0.1048p pd=0.97u as=0.13545p ps=1.065u w=0.645u l=0.6u
C0 VNW VPW 4.44444f
.ends

* NGSPICE file created from gf180mcu_fd_sc_mcu7t5v0__sdffrnq_2.ext - technology: gf180mcuD

.subckt gf180mcu_fd_sc_mcu7t5v0__sdffrnq_2 D RN SE SI CLK Q VDD VNW VPW VSS
X0 a_2358_502# RN VDD VNW pfet_05v0 ad=0.2772p pd=2.14u as=0.3312p ps=1.75u w=0.63u l=0.5u
X1 Q a_3690_141# VDD VNW pfet_05v0 ad=0.34627p pd=1.785u as=0.5346p ps=3.31u w=1.215u l=0.5u
X2 a_2404_124# a_1748_497# a_2154_502# VPW nfet_05v0 ad=43.2f pd=0.6u as=93.59999f ps=0.88u w=0.36u l=0.6u
X3 a_3572_185# a_1285_502# a_3348_185# VPW nfet_05v0 ad=0.1062p pd=0.95u as=93.59999f ps=0.88u w=0.36u l=0.6u
X4 a_2154_502# a_1748_497# a_596_502# VNW pfet_05v0 ad=0.1638p pd=1.15u as=0.2772p ps=2.14u w=0.63u l=0.5u
X5 VSS a_3690_141# a_3572_185# VPW nfet_05v0 ad=0.2547p pd=1.625u as=0.1062p ps=0.95u w=0.36u l=0.6u
X6 Q a_3690_141# VSS VPW nfet_05v0 ad=0.2106p pd=1.33u as=0.3564p ps=2.5u w=0.81u l=0.6u
X7 a_636_156# SE a_468_156# VPW nfet_05v0 ad=93.59999f pd=0.88u as=43.2f ps=0.6u w=0.36u l=0.6u
X8 a_1748_497# a_1285_502# VSS VPW nfet_05v0 ad=0.3519p pd=2.5u as=0.2046p ps=1.81u w=0.465u l=0.6u
X9 a_3690_141# a_3348_185# a_4122_124# VPW nfet_05v0 ad=0.2376p pd=1.96u as=86.39999f ps=0.86u w=0.54u l=0.6u
X10 VSS RN a_2572_124# VPW nfet_05v0 ad=0.2277p pd=1.625u as=0.108p ps=0.96u w=0.36u l=0.6u
X11 a_2358_502# a_1285_502# a_2154_502# VNW pfet_05v0 ad=0.1638p pd=1.15u as=0.1638p ps=1.15u w=0.63u l=0.5u
X12 VDD a_2452_80# a_2358_502# VNW pfet_05v0 ad=0.3312p pd=1.75u as=0.1638p ps=1.15u w=0.63u l=0.5u
X13 a_448_502# SI VDD VNW pfet_05v0 ad=75.59999f pd=0.87u as=0.1953p ps=1.25u w=0.63u l=0.5u
X14 a_468_156# SI VSS VPW nfet_05v0 ad=43.2f pd=0.6u as=93.59999f ps=0.88u w=0.36u l=0.6u
X15 a_596_502# a_36_156# a_448_502# VNW pfet_05v0 ad=0.2268p pd=1.35u as=75.59999f ps=0.87u w=0.63u l=0.5u
X16 a_2154_502# a_1285_502# a_636_156# VPW nfet_05v0 ad=93.59999f pd=0.88u as=0.1584p ps=1.6u w=0.36u l=0.6u
X17 a_1285_502# CLK VDD VNW pfet_05v0 ad=0.4995p pd=2.93u as=0.4113p ps=1.91u w=0.925u l=0.5u
X18 a_2452_80# a_2154_502# VDD VNW pfet_05v0 ad=0.1638p pd=1.15u as=0.2772p ps=2.14u w=0.63u l=0.5u
X19 a_3348_185# a_1748_497# a_2452_80# VPW nfet_05v0 ad=93.59999f pd=0.88u as=93.59999f ps=0.88u w=0.36u l=0.6u
X20 a_3690_141# RN VDD VNW pfet_05v0 ad=0.2392p pd=1.44u as=0.3222p ps=1.715u w=0.92u l=0.5u
X21 VSS a_36_156# a_860_156# VPW nfet_05v0 ad=0.1644p pd=1.25u as=43.2f ps=0.6u w=0.36u l=0.6u
X22 a_3348_185# a_1285_502# a_2452_80# VNW pfet_05v0 ad=0.20947p pd=1.295u as=0.1638p ps=1.15u w=0.63u l=0.5u
X23 VDD a_3348_185# a_3690_141# VNW pfet_05v0 ad=0.4048p pd=2.72u as=0.2392p ps=1.44u w=0.92u l=0.5u
X24 a_840_502# D a_596_502# VNW pfet_05v0 ad=75.59999f pd=0.87u as=0.2268p ps=1.35u w=0.63u l=0.5u
X25 VDD SE a_36_156# VNW pfet_05v0 ad=0.1953p pd=1.25u as=0.2772p ps=2.14u w=0.63u l=0.5u
X26 a_860_156# D a_636_156# VPW nfet_05v0 ad=43.2f pd=0.6u as=93.59999f ps=0.88u w=0.36u l=0.6u
X27 a_1748_497# a_1285_502# VDD VNW pfet_05v0 ad=0.3586p pd=2.51u as=0.6621p ps=3.64u w=0.815u l=0.5u
X28 a_3572_185# a_1748_497# a_3348_185# VNW pfet_05v0 ad=0.1638p pd=1.15u as=0.20947p ps=1.295u w=0.63u l=0.5u
X29 VSS SE a_36_156# VPW nfet_05v0 ad=93.59999f pd=0.88u as=0.1584p ps=1.6u w=0.36u l=0.6u
X30 a_1285_502# CLK VSS VPW nfet_05v0 ad=0.3591p pd=2.54u as=0.1644p ps=1.25u w=0.465u l=0.6u
X31 VDD SE a_840_502# VNW pfet_05v0 ad=0.4113p pd=1.91u as=75.59999f ps=0.87u w=0.63u l=0.5u
X32 a_2572_124# a_2452_80# a_2404_124# VPW nfet_05v0 ad=0.108p pd=0.96u as=43.2f ps=0.6u w=0.36u l=0.6u
X33 a_4122_124# RN VSS VPW nfet_05v0 ad=86.39999f pd=0.86u as=0.2547p ps=1.625u w=0.54u l=0.6u
X34 VSS a_3690_141# Q VPW nfet_05v0 ad=0.3564p pd=2.5u as=0.2106p ps=1.33u w=0.81u l=0.6u
X35 VDD a_3690_141# a_3572_185# VNW pfet_05v0 ad=0.3222p pd=1.715u as=0.1638p ps=1.15u w=0.63u l=0.5u
X36 VDD a_3690_141# Q VNW pfet_05v0 ad=0.5346p pd=3.31u as=0.34627p ps=1.785u w=1.215u l=0.5u
X37 a_2452_80# a_2154_502# VSS VPW nfet_05v0 ad=93.59999f pd=0.88u as=0.2277p ps=1.625u w=0.36u l=0.6u
C0 VNW VPW 7.87715f
.ends

* NGSPICE file created from gf180mcu_fd_sc_mcu7t5v0__latq_4.ext - technology: gf180mcuD

.subckt gf180mcu_fd_sc_mcu7t5v0__latq_4 D E Q VDD VNW VPW VSS
X0 Q a_1020_590# VDD VNW pfet_05v0 ad=0.3172p pd=1.74u as=0.49965p ps=2.16u w=1.22u l=0.5u
X1 a_1020_590# a_484_591# a_872_86# VPW nfet_05v0 ad=0.1027p pd=0.915u as=47.4f ps=0.635u w=0.395u l=0.6u
X2 VSS a_1020_590# Q VPW nfet_05v0 ad=0.3608p pd=2.52u as=0.2132p ps=1.34u w=0.82u l=0.6u
X3 VSS a_1020_590# a_1404_42# VPW nfet_05v0 ad=0.25015p pd=1.56u as=0.1209p ps=0.985u w=0.465u l=0.6u
X4 VSS a_1020_590# Q VPW nfet_05v0 ad=0.2132p pd=1.34u as=0.2132p ps=1.34u w=0.82u l=0.6u
X5 VSS a_1404_42# a_1264_86# VPW nfet_05v0 ad=0.1209p pd=0.985u as=0.15225p ps=1.165u w=0.465u l=0.6u
X6 VDD a_1020_590# Q VNW pfet_05v0 ad=0.3172p pd=1.74u as=0.3172p ps=1.74u w=1.22u l=0.5u
X7 a_1020_590# a_36_87# a_872_590# VNW pfet_05v0 ad=0.1638p pd=1.15u as=75.59999f ps=0.87u w=0.63u l=0.5u
X8 VSS E a_36_87# VPW nfet_05v0 ad=0.1505p pd=1.16u as=0.2024p ps=1.8u w=0.46u l=0.6u
X9 Q a_1020_590# VDD VNW pfet_05v0 ad=0.3172p pd=1.74u as=0.3172p ps=1.74u w=1.22u l=0.5u
X10 VDD E a_36_87# VNW pfet_05v0 ad=0.27775p pd=1.62u as=0.4048p ps=2.72u w=0.92u l=0.5u
X11 VDD a_1020_590# Q VNW pfet_05v0 ad=0.8845p pd=3.89u as=0.3172p ps=1.74u w=1.22u l=0.5u
X12 a_1224_590# a_484_591# a_1020_590# VNW pfet_05v0 ad=0.38875p pd=1.925u as=0.1638p ps=1.15u w=0.63u l=0.5u
X13 Q a_1020_590# VSS VPW nfet_05v0 ad=0.2132p pd=1.34u as=0.25015p ps=1.56u w=0.82u l=0.6u
X14 a_484_591# a_36_87# VDD VNW pfet_05v0 ad=0.3375p pd=2.33u as=0.27775p ps=1.62u w=0.625u l=0.5u
X15 a_1264_86# a_36_87# a_1020_590# VPW nfet_05v0 ad=0.15225p pd=1.165u as=0.1027p ps=0.915u w=0.395u l=0.6u
X16 VDD a_1404_42# a_1224_590# VNW pfet_05v0 ad=0.2405p pd=1.445u as=0.38875p ps=1.925u w=0.925u l=0.5u
X17 a_1404_42# a_1020_590# VDD VNW pfet_05v0 ad=0.2405p pd=1.445u as=0.2405p ps=1.445u w=0.925u l=0.5u
X18 a_484_591# a_36_87# VSS VPW nfet_05v0 ad=0.1716p pd=1.66u as=0.1505p ps=1.16u w=0.39u l=0.6u
X19 Q a_1020_590# VSS VPW nfet_05v0 ad=0.2132p pd=1.34u as=0.2132p ps=1.34u w=0.82u l=0.6u
X20 a_1404_42# a_1020_590# VSS VPW nfet_05v0 ad=0.1209p pd=0.985u as=0.1209p ps=0.985u w=0.465u l=0.6u
X21 a_872_590# D VDD VNW pfet_05v0 ad=75.59999f pd=0.87u as=0.2772p ps=2.14u w=0.63u l=0.5u
X22 VDD a_1020_590# a_1404_42# VNW pfet_05v0 ad=0.49965p pd=2.16u as=0.2405p ps=1.445u w=0.925u l=0.5u
X23 a_872_86# D VSS VPW nfet_05v0 ad=47.4f pd=0.635u as=0.1738p ps=1.67u w=0.395u l=0.6u
C0 VNW VPW 5.14063f
.ends

* NGSPICE file created from gf180mcu_fd_sc_mcu7t5v0__latq_2.ext - technology: gf180mcuD

.subckt gf180mcu_fd_sc_mcu7t5v0__latq_2 D E Q VDD VNW VPW VSS
X0 a_1020_590# a_484_591# a_872_86# VPW nfet_05v0 ad=0.1027p pd=0.915u as=47.4f ps=0.635u w=0.395u l=0.6u
X1 a_1364_316# a_1020_590# VDD VNW pfet_05v0 ad=0.407p pd=2.73u as=0.2405p ps=1.445u w=0.925u l=0.5u
X2 VSS a_1364_316# a_1264_86# VPW nfet_05v0 ad=0.1209p pd=0.985u as=0.15225p ps=1.165u w=0.465u l=0.6u
X3 VSS a_1020_590# Q VPW nfet_05v0 ad=0.3608p pd=2.52u as=0.2132p ps=1.34u w=0.82u l=0.6u
X4 a_1020_590# a_36_87# a_872_590# VNW pfet_05v0 ad=0.1638p pd=1.15u as=75.59999f ps=0.87u w=0.63u l=0.5u
X5 VSS E a_36_87# VPW nfet_05v0 ad=0.1505p pd=1.16u as=0.2024p ps=1.8u w=0.46u l=0.6u
X6 a_1224_590# a_484_591# a_1020_590# VNW pfet_05v0 ad=0.2795p pd=1.625u as=0.1638p ps=1.15u w=0.63u l=0.5u
X7 a_484_591# a_36_87# VDD VNW pfet_05v0 ad=0.3375p pd=2.33u as=0.32375p ps=1.72u w=0.625u l=0.5u
X8 a_1264_86# a_36_87# a_1020_590# VPW nfet_05v0 ad=0.15225p pd=1.165u as=0.1027p ps=0.915u w=0.395u l=0.6u
X9 Q a_1020_590# VDD VNW pfet_05v0 ad=0.3172p pd=1.74u as=0.5368p ps=3.32u w=1.22u l=0.5u
X10 Q a_1020_590# VSS VPW nfet_05v0 ad=0.2132p pd=1.34u as=0.3608p ps=2.52u w=0.82u l=0.6u
X11 VDD a_1020_590# Q VNW pfet_05v0 ad=0.5368p pd=3.32u as=0.3172p ps=1.74u w=1.22u l=0.5u
X12 VDD E a_36_87# VNW pfet_05v0 ad=0.32375p pd=1.72u as=0.4048p ps=2.72u w=0.92u l=0.5u
X13 a_484_591# a_36_87# VSS VPW nfet_05v0 ad=0.1716p pd=1.66u as=0.1505p ps=1.16u w=0.39u l=0.6u
X14 a_1364_316# a_1020_590# VSS VPW nfet_05v0 ad=0.2046p pd=1.81u as=0.1209p ps=0.985u w=0.465u l=0.6u
X15 a_872_590# D VDD VNW pfet_05v0 ad=75.59999f pd=0.87u as=0.2772p ps=2.14u w=0.63u l=0.5u
X16 VDD a_1364_316# a_1224_590# VNW pfet_05v0 ad=0.2405p pd=1.445u as=0.2795p ps=1.625u w=0.925u l=0.5u
X17 a_872_86# D VSS VPW nfet_05v0 ad=47.4f pd=0.635u as=0.1738p ps=1.67u w=0.395u l=0.6u
C0 VNW VPW 4.09634f
.ends

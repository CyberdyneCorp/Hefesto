* NGSPICE file created from gf180mcu_fd_sc_mcu7t5v0__sdffsnq_4.ext - technology: gf180mcuD

.subckt gf180mcu_fd_sc_mcu7t5v0__sdffsnq_4 D SE SETN SI CLK Q VDD VNW VPW VSS
X0 VDD a_4197_114# Q VNW pfet_05v0 ad=0.3233p pd=1.75u as=0.32635p ps=1.755u w=1.22u l=0.5u
X1 a_2540_426# SETN a_3020_185# VPW nfet_05v0 ad=93.59999f pd=0.88u as=43.2f ps=0.6u w=0.36u l=0.6u
X2 VDD a_4197_114# a_3636_185# VNW pfet_05v0 ad=0.3508p pd=2u as=0.1222p ps=0.99u w=0.47u l=0.5u
X3 a_448_556# SI VDD VNW pfet_05v0 ad=43.2f pd=0.6u as=0.1116p ps=0.98u w=0.36u l=0.5u
X4 VSS a_2540_426# a_2552_124# VPW nfet_05v0 ad=0.225p pd=1.565u as=57f ps=0.715u w=0.475u l=0.6u
X5 a_636_156# SE a_468_156# VPW nfet_05v0 ad=98.8f pd=0.9u as=45.6f ps=0.62u w=0.38u l=0.6u
X6 a_596_556# a_36_156# a_448_556# VNW pfet_05v0 ad=0.1296p pd=1.08u as=43.2f ps=0.6u w=0.36u l=0.5u
X7 a_1850_497# a_1300_144# VSS VPW nfet_05v0 ad=0.36615p pd=2.55u as=0.32737p ps=1.995u w=0.465u l=0.6u
X8 a_2552_124# a_1850_497# a_2288_518# VPW nfet_05v0 ad=57f pd=0.715u as=0.1235p ps=0.995u w=0.475u l=0.6u
X9 a_468_156# SI VSS VPW nfet_05v0 ad=45.6f pd=0.62u as=98.8f ps=0.9u w=0.38u l=0.6u
X10 a_4197_114# a_3412_185# VDD VNW pfet_05v0 ad=0.3172p pd=1.74u as=0.3508p ps=2u w=1.22u l=0.5u
X11 Q a_4197_114# VDD VNW pfet_05v0 ad=0.4026p pd=1.88u as=0.3233p ps=1.75u w=1.22u l=0.5u
X12 VDD a_4197_114# Q VNW pfet_05v0 ad=0.5368p pd=3.32u as=0.4026p ps=1.88u w=1.22u l=0.5u
X13 a_2288_518# a_1850_497# a_596_556# VNW pfet_05v0 ad=93.59999f pd=0.88u as=0.1584p ps=1.6u w=0.36u l=0.5u
X14 a_840_556# D a_596_556# VNW pfet_05v0 ad=43.2f pd=0.6u as=0.1296p ps=1.08u w=0.36u l=0.5u
X15 a_3636_185# a_1300_144# a_3412_185# VPW nfet_05v0 ad=0.1584p pd=1.6u as=93.59999f ps=0.88u w=0.36u l=0.6u
X16 VDD SE a_36_156# VNW pfet_05v0 ad=0.1116p pd=0.98u as=0.1584p ps=1.6u w=0.36u l=0.5u
X17 VDD CLK a_1300_144# VNW pfet_05v0 ad=0.50627p pd=2.25u as=0.3586p ps=2.51u w=0.815u l=0.5u
X18 a_2492_518# a_1300_144# a_2288_518# VNW pfet_05v0 ad=43.2f pd=0.6u as=93.59999f ps=0.88u w=0.36u l=0.5u
X19 VDD a_3412_185# a_4197_114# VNW pfet_05v0 ad=0.3172p pd=1.74u as=0.3172p ps=1.74u w=1.22u l=0.5u
X20 VSS a_4197_114# a_4149_158# VPW nfet_05v0 ad=0.2348p pd=1.555u as=44.4f ps=0.61u w=0.37u l=0.6u
X21 VDD SETN a_2540_426# VNW pfet_05v0 ad=0.3586p pd=2.51u as=0.2119p ps=1.335u w=0.815u l=0.5u
X22 VSS a_36_156# a_860_156# VPW nfet_05v0 ad=0.4668p pd=3.28u as=45.6f ps=0.62u w=0.38u l=0.6u
X23 VSS a_3412_185# a_4197_114# VPW nfet_05v0 ad=0.2119p pd=1.335u as=0.2119p ps=1.335u w=0.815u l=0.6u
X24 VDD SE a_840_556# VNW pfet_05v0 ad=0.4032p pd=2.96u as=43.2f ps=0.6u w=0.36u l=0.5u
X25 a_3412_185# a_1850_497# a_2540_426# VPW nfet_05v0 ad=93.59999f pd=0.88u as=93.59999f ps=0.88u w=0.36u l=0.6u
X26 Q a_4197_114# VDD VNW pfet_05v0 ad=0.32635p pd=1.755u as=0.3172p ps=1.74u w=1.22u l=0.5u
X27 a_3412_185# a_1300_144# a_2540_426# VNW pfet_05v0 ad=0.1079p pd=0.935u as=0.1826p ps=1.71u w=0.415u l=0.5u
X28 a_2540_426# a_2288_518# VDD VNW pfet_05v0 ad=0.2119p pd=1.335u as=0.45205p ps=2.29u w=0.815u l=0.5u
X29 VSS a_4197_114# Q VPW nfet_05v0 ad=0.3586p pd=2.51u as=0.2119p ps=1.335u w=0.815u l=0.6u
X30 a_860_156# D a_636_156# VPW nfet_05v0 ad=45.6f pd=0.62u as=98.8f ps=0.9u w=0.38u l=0.6u
X31 a_3020_185# a_2288_518# VSS VPW nfet_05v0 ad=43.2f pd=0.6u as=0.225p ps=1.565u w=0.36u l=0.6u
X32 a_3636_185# a_1850_497# a_3412_185# VNW pfet_05v0 ad=0.1826p pd=1.71u as=0.1079p ps=0.935u w=0.415u l=0.5u
X33 VSS SE a_36_156# VPW nfet_05v0 ad=98.8f pd=0.9u as=0.1672p ps=1.64u w=0.38u l=0.6u
X34 a_2288_518# a_1300_144# a_636_156# VPW nfet_05v0 ad=0.1235p pd=0.995u as=0.209p ps=1.83u w=0.475u l=0.6u
X35 VSS a_4197_114# Q VPW nfet_05v0 ad=0.2119p pd=1.335u as=0.2119p ps=1.335u w=0.815u l=0.6u
X36 a_1850_497# a_1300_144# VDD VNW pfet_05v0 ad=0.3586p pd=2.51u as=0.50627p ps=2.25u w=0.815u l=0.5u
X37 Q a_4197_114# VSS VPW nfet_05v0 ad=0.2119p pd=1.335u as=0.2119p ps=1.335u w=0.815u l=0.6u
X38 VDD a_2540_426# a_2492_518# VNW pfet_05v0 ad=0.45205p pd=2.29u as=43.2f ps=0.6u w=0.36u l=0.5u
X39 a_4197_114# a_3412_185# VSS VPW nfet_05v0 ad=0.2119p pd=1.335u as=0.2348p ps=1.555u w=0.815u l=0.6u
X40 VSS CLK a_1300_144# VPW nfet_05v0 ad=0.32737p pd=1.995u as=0.3429p ps=2.45u w=0.465u l=0.6u
X41 a_3636_185# SETN VDD VNW pfet_05v0 ad=0.1222p pd=0.99u as=0.2068p ps=1.82u w=0.47u l=0.5u
X42 a_4149_158# SETN a_3636_185# VPW nfet_05v0 ad=44.4f pd=0.61u as=0.31325p ps=2.44u w=0.37u l=0.6u
X43 Q a_4197_114# VSS VPW nfet_05v0 ad=0.2119p pd=1.335u as=0.2119p ps=1.335u w=0.815u l=0.6u
C0 VNW VPW 9.26113f
.ends

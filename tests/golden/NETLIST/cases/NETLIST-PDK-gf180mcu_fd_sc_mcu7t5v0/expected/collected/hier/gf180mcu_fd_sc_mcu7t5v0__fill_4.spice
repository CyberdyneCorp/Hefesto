* NGSPICE file created from gf180mcu_fd_sc_mcu7t5v0__fill_4.ext - technology: gf180mcuD

.subckt gf180mcu_fd_sc_mcu7t5v0__fill_4 VDD VNW VPW VSS
.ends

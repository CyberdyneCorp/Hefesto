* NGSPICE file created from gf180mcu_fd_sc_mcu7t5v0__fill_8.ext - technology: gf180mcuD

.subckt gf180mcu_fd_sc_mcu7t5v0__fill_8 VDD VNW VPW VSS
.ends

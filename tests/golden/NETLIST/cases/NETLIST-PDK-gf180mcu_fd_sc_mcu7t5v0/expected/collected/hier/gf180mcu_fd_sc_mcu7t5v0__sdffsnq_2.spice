* NGSPICE file created from gf180mcu_fd_sc_mcu7t5v0__sdffsnq_2.ext - technology: gf180mcuD

.subckt gf180mcu_fd_sc_mcu7t5v0__sdffsnq_2 D SE SETN SI CLK Q VDD VNW VPW VSS
X0 a_3524_185# SETN VDD VNW pfet_05v0 ad=0.1625p pd=1.145u as=0.2875p ps=2.17u w=0.625u l=0.5u
X1 a_2404_124# a_1748_497# a_2096_497# VPW nfet_05v0 ad=75.59999f pd=0.78u as=93.59999f ps=0.88u w=0.36u l=0.6u
X2 VSS a_2476_430# a_2404_124# VPW nfet_05v0 ad=0.20775p pd=1.565u as=75.59999f ps=0.78u w=0.36u l=0.6u
X3 Q a_4110_62# VSS VPW nfet_05v0 ad=0.2132p pd=1.34u as=0.3608p ps=2.52u w=0.82u l=0.6u
X4 a_636_156# SE a_468_156# VPW nfet_05v0 ad=93.59999f pd=0.88u as=43.2f ps=0.6u w=0.36u l=0.6u
X5 a_1748_497# a_1285_502# VSS VPW nfet_05v0 ad=0.3519p pd=2.5u as=0.2046p ps=1.81u w=0.465u l=0.6u
X6 a_4110_62# a_3300_185# VSS VPW nfet_05v0 ad=0.3608p pd=2.52u as=0.218p ps=1.52u w=0.82u l=0.6u
X7 a_2336_474# a_1285_502# a_2096_497# VNW pfet_05v0 ad=0.22925p pd=1.535u as=0.2245p ps=1.44u w=0.625u l=0.5u
X8 VSS a_4110_62# a_4005_106# VPW nfet_05v0 ad=0.218p pd=1.52u as=94.5f ps=0.885u w=0.36u l=0.6u
X9 a_2096_497# a_1748_497# a_596_502# VNW pfet_05v0 ad=0.2245p pd=1.44u as=0.275p ps=2.13u w=0.625u l=0.5u
X10 VDD SETN a_2476_430# VNW pfet_05v0 ad=0.275p pd=2.13u as=0.16875p ps=1.165u w=0.625u l=0.5u
X11 a_448_502# SI VDD VNW pfet_05v0 ad=75.59999f pd=0.87u as=0.1953p ps=1.25u w=0.63u l=0.5u
X12 a_3300_185# a_1285_502# a_2476_430# VNW pfet_05v0 ad=0.1625p pd=1.145u as=0.275p ps=2.13u w=0.625u l=0.5u
X13 a_468_156# SI VSS VPW nfet_05v0 ad=43.2f pd=0.6u as=93.59999f ps=0.88u w=0.36u l=0.6u
X14 VDD a_4110_62# Q VNW pfet_05v0 ad=0.5368p pd=3.32u as=0.32635p ps=1.755u w=1.22u l=0.5u
X15 a_596_502# a_36_156# a_448_502# VNW pfet_05v0 ad=0.2268p pd=1.35u as=75.59999f ps=0.87u w=0.63u l=0.5u
X16 a_3524_185# a_1748_497# a_3300_185# VNW pfet_05v0 ad=0.2875p pd=2.17u as=0.1625p ps=1.145u w=0.625u l=0.5u
X17 VSS a_4110_62# Q VPW nfet_05v0 ad=0.3608p pd=2.52u as=0.2132p ps=1.34u w=0.82u l=0.64u
X18 a_2096_497# a_1285_502# a_636_156# VPW nfet_05v0 ad=93.59999f pd=0.88u as=0.1584p ps=1.6u w=0.36u l=0.6u
X19 a_1285_502# CLK VDD VNW pfet_05v0 ad=0.4995p pd=2.93u as=0.4113p ps=1.91u w=0.925u l=0.5u
X20 a_4005_106# SETN a_3524_185# VPW nfet_05v0 ad=94.5f pd=0.885u as=0.1584p ps=1.6u w=0.36u l=0.6u
X21 a_2476_430# a_2096_497# VDD VNW pfet_05v0 ad=0.16875p pd=1.165u as=0.3963p ps=2.12u w=0.625u l=0.5u
X22 a_4110_62# a_3300_185# VDD VNW pfet_05v0 ad=0.5368p pd=3.32u as=0.33775p ps=1.92u w=1.22u l=0.5u
X23 a_2476_430# SETN a_2908_185# VPW nfet_05v0 ad=93.59999f pd=0.88u as=43.2f ps=0.6u w=0.36u l=0.6u
X24 VSS a_36_156# a_860_156# VPW nfet_05v0 ad=0.1644p pd=1.25u as=43.2f ps=0.6u w=0.36u l=0.6u
X25 a_840_502# D a_596_502# VNW pfet_05v0 ad=75.59999f pd=0.87u as=0.2268p ps=1.35u w=0.63u l=0.5u
X26 a_3524_185# a_1285_502# a_3300_185# VPW nfet_05v0 ad=0.1584p pd=1.6u as=93.59999f ps=0.88u w=0.36u l=0.6u
X27 VDD SE a_36_156# VNW pfet_05v0 ad=0.1953p pd=1.25u as=0.2772p ps=2.14u w=0.63u l=0.5u
X28 a_860_156# D a_636_156# VPW nfet_05v0 ad=43.2f pd=0.6u as=93.59999f ps=0.88u w=0.36u l=0.6u
X29 Q a_4110_62# VDD VNW pfet_05v0 ad=0.32635p pd=1.755u as=0.5368p ps=3.32u w=1.22u l=0.5u
X30 a_2908_185# a_2096_497# VSS VPW nfet_05v0 ad=43.2f pd=0.6u as=0.20775p ps=1.565u w=0.36u l=0.6u
X31 a_1748_497# a_1285_502# VDD VNW pfet_05v0 ad=0.3586p pd=2.51u as=0.6621p ps=3.64u w=0.815u l=0.5u
X32 VSS SE a_36_156# VPW nfet_05v0 ad=93.59999f pd=0.88u as=0.1584p ps=1.6u w=0.36u l=0.6u
X33 a_1285_502# CLK VSS VPW nfet_05v0 ad=0.3591p pd=2.54u as=0.1644p ps=1.25u w=0.465u l=0.6u
X34 VDD SE a_840_502# VNW pfet_05v0 ad=0.4113p pd=1.91u as=75.59999f ps=0.87u w=0.63u l=0.5u
X35 VDD a_2476_430# a_2336_474# VNW pfet_05v0 ad=0.3963p pd=2.12u as=0.22925p ps=1.535u w=0.625u l=0.5u
X36 VDD a_4110_62# a_3524_185# VNW pfet_05v0 ad=0.33775p pd=1.92u as=0.1625p ps=1.145u w=0.625u l=0.5u
X37 a_3300_185# a_1748_497# a_2476_430# VPW nfet_05v0 ad=93.59999f pd=0.88u as=93.59999f ps=0.88u w=0.36u l=0.6u
C0 VNW VPW 8.31112f
.ends

* NGSPICE file created from gf180mcu_fd_sc_mcu7t5v0__dlya_4.ext - technology: gf180mcuD

.subckt gf180mcu_fd_sc_mcu7t5v0__dlya_4 I Z VDD VNW VPW VSS
X0 Z a_629_110# VDD VNW pfet_05v0 ad=0.3477p pd=1.79u as=0.3782p ps=1.84u w=1.22u l=0.5u
X1 VSS a_629_110# Z VPW nfet_05v0 ad=0.2132p pd=1.34u as=0.2132p ps=1.34u w=0.82u l=0.6u
X2 VSS I a_37_110# VPW nfet_05v0 ad=93.59999f pd=0.88u as=0.1584p ps=1.6u w=0.36u l=0.6u
X3 VDD a_449_526# a_629_110# VNW pfet_05v0 ad=0.3285p pd=1.97u as=0.1584p ps=1.6u w=0.36u l=0.5u
X4 a_449_526# a_37_110# VDD VNW pfet_05v0 ad=0.1584p pd=1.6u as=0.1116p ps=0.98u w=0.36u l=0.5u
X5 VDD a_629_110# Z VNW pfet_05v0 ad=0.3782p pd=1.84u as=0.4087p ps=1.89u w=1.22u l=0.5u
X6 VSS a_629_110# Z VPW nfet_05v0 ad=0.3608p pd=2.52u as=0.2132p ps=1.34u w=0.82u l=0.6u
X7 VDD I a_37_110# VNW pfet_05v0 ad=0.1116p pd=0.98u as=0.1584p ps=1.6u w=0.36u l=0.5u
X8 Z a_629_110# VDD VNW pfet_05v0 ad=0.4087p pd=1.89u as=0.3285p ps=1.97u w=1.22u l=0.5u
X9 a_449_526# a_37_110# VSS VPW nfet_05v0 ad=0.1584p pd=1.6u as=93.59999f ps=0.88u w=0.36u l=0.6u
X10 Z a_629_110# VSS VPW nfet_05v0 ad=0.2132p pd=1.34u as=0.2132p ps=1.34u w=0.82u l=0.6u
X11 VDD a_629_110# Z VNW pfet_05v0 ad=0.5368p pd=3.32u as=0.3477p ps=1.79u w=1.22u l=0.5u
X12 Z a_629_110# VSS VPW nfet_05v0 ad=0.2132p pd=1.34u as=0.218p ps=1.52u w=0.82u l=0.6u
X13 VSS a_449_526# a_629_110# VPW nfet_05v0 ad=0.218p pd=1.52u as=0.1584p ps=1.6u w=0.36u l=0.6u
C0 VNW VPW 3.2261f
.ends

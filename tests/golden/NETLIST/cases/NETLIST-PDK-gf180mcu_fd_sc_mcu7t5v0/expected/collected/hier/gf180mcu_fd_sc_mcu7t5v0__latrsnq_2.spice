* NGSPICE file created from gf180mcu_fd_sc_mcu7t5v0__latrsnq_2.ext - technology: gf180mcuD

.subckt gf180mcu_fd_sc_mcu7t5v0__latrsnq_2 D E RN SETN Q VDD VNW VPW VSS
X0 a_1132_590# E a_388_590# VNW pfet_05v0 ad=94.5f pd=0.93u as=0.1638p ps=1.15u w=0.63u l=0.5u
X1 a_504_93# RN VSS VPW nfet_05v0 ad=47.4f pd=0.635u as=0.15225p ps=1.165u w=0.395u l=0.6u
X2 a_672_93# D a_504_93# VPW nfet_05v0 ad=47.4f pd=0.635u as=47.4f ps=0.635u w=0.395u l=0.6u
X3 a_388_590# E a_672_93# VPW nfet_05v0 ad=0.1027p pd=0.915u as=47.4f ps=0.635u w=0.395u l=0.6u
X4 VDD a_1112_24# a_1132_590# VNW pfet_05v0 ad=0.3087p pd=1.61u as=94.5f ps=0.93u w=0.63u l=0.5u
X5 VSS E a_36_79# VPW nfet_05v0 ad=0.15225p pd=1.165u as=0.2046p ps=1.81u w=0.465u l=0.6u
X6 Q a_2016_68# VDD VNW pfet_05v0 ad=0.3172p pd=1.74u as=0.3782p ps=1.84u w=1.22u l=0.5u
X7 a_1660_93# a_388_590# VSS VPW nfet_05v0 ad=69.75f pd=0.765u as=0.15225p ps=1.165u w=0.465u l=0.6u
X8 VDD a_2016_68# Q VNW pfet_05v0 ad=0.5368p pd=3.32u as=0.3172p ps=1.74u w=1.22u l=0.5u
X9 VDD E a_36_79# VNW pfet_05v0 ad=0.407p pd=2.73u as=0.407p ps=2.73u w=0.925u l=0.5u
X10 VDD RN a_388_590# VNW pfet_05v0 ad=0.1638p pd=1.15u as=0.2772p ps=2.14u w=0.63u l=0.5u
X11 a_1112_24# SETN a_1660_93# VPW nfet_05v0 ad=0.2046p pd=1.81u as=69.75f ps=0.765u w=0.465u l=0.6u
X12 a_780_590# D VDD VNW pfet_05v0 ad=75.59999f pd=0.87u as=0.1638p ps=1.15u w=0.63u l=0.5u
X13 VDD SETN a_1112_24# VNW pfet_05v0 ad=0.407p pd=2.73u as=0.30725p ps=1.685u w=0.925u l=0.5u
X14 Q a_2016_68# VSS VPW nfet_05v0 ad=0.2132p pd=1.34u as=0.2132p ps=1.34u w=0.82u l=0.6u
X15 a_1112_24# a_388_590# VDD VNW pfet_05v0 ad=0.30725p pd=1.685u as=0.3087p ps=1.61u w=0.63u l=0.5u
X16 VDD a_1112_24# a_2016_68# VNW pfet_05v0 ad=0.3782p pd=1.84u as=0.5368p ps=3.32u w=1.22u l=0.5u
X17 a_1232_93# a_1112_24# a_1064_93# VPW nfet_05v0 ad=47.4f pd=0.635u as=47.4f ps=0.635u w=0.395u l=0.6u
X18 VSS a_2016_68# Q VPW nfet_05v0 ad=0.3608p pd=2.52u as=0.2132p ps=1.34u w=0.82u l=0.6u
X19 a_388_590# a_36_79# a_780_590# VNW pfet_05v0 ad=0.1638p pd=1.15u as=75.59999f ps=0.87u w=0.63u l=0.5u
X20 a_1064_93# a_36_79# a_388_590# VPW nfet_05v0 ad=47.4f pd=0.635u as=0.1027p ps=0.915u w=0.395u l=0.6u
X21 VSS RN a_1232_93# VPW nfet_05v0 ad=0.15225p pd=1.165u as=47.4f ps=0.635u w=0.395u l=0.6u
X22 VSS a_1112_24# a_2016_68# VPW nfet_05v0 ad=0.2132p pd=1.34u as=0.3608p ps=2.52u w=0.82u l=0.6u
C0 VNW VPW 4.61849f
.ends

* NGSPICE file created from gf180mcu_fd_sc_mcu7t5v0__xnor2_2.ext - technology: gf180mcuD

.subckt gf180mcu_fd_sc_mcu7t5v0__xnor2_2 A1 A2 ZN VDD VNW VPW VSS
X0 a_728_472# a_56_565# VDD VNW pfet_05v0 ad=0.3172p pd=1.74u as=0.37112p ps=2.07u w=1.22u l=0.5u
X1 ZN a_728_68# VSS VPW nfet_05v0 ad=0.2132p pd=1.34u as=0.3608p ps=2.52u w=0.82u l=0.6u
X2 a_728_68# A1 a_728_472# VNW pfet_05v0 ad=0.3172p pd=1.74u as=0.3172p ps=1.74u w=1.22u l=0.5u
X3 VDD A1 a_244_565# VNW pfet_05v0 ad=0.37112p pd=2.07u as=0.16102p ps=1.135u w=0.565u l=0.5u
X4 VSS A1 a_56_565# VPW nfet_05v0 ad=0.218p pd=1.52u as=93.59999f ps=0.88u w=0.36u l=0.6u
X5 a_244_565# A2 a_56_565# VNW pfet_05v0 ad=0.16102p pd=1.135u as=0.2486p ps=2.01u w=0.565u l=0.5u
X6 a_728_472# A2 a_728_68# VNW pfet_05v0 ad=0.5368p pd=3.32u as=0.3172p ps=1.74u w=1.22u l=0.5u
X7 a_728_68# a_56_565# VSS VPW nfet_05v0 ad=0.2132p pd=1.34u as=0.218p ps=1.52u w=0.82u l=0.6u
X8 VSS A2 a_952_68# VPW nfet_05v0 ad=0.3608p pd=2.52u as=0.1312p ps=1.14u w=0.82u l=0.6u
X9 a_56_565# A2 VSS VPW nfet_05v0 ad=93.59999f pd=0.88u as=0.1584p ps=1.6u w=0.36u l=0.6u
X10 a_952_68# A1 a_728_68# VPW nfet_05v0 ad=0.1312p pd=1.14u as=0.2132p ps=1.34u w=0.82u l=0.6u
X11 VDD a_728_68# ZN VNW pfet_05v0 ad=0.5368p pd=3.32u as=0.3782p ps=1.84u w=1.22u l=0.5u
X12 VSS a_728_68# ZN VPW nfet_05v0 ad=0.3608p pd=2.52u as=0.2132p ps=1.34u w=0.82u l=0.6u
X13 ZN a_728_68# VDD VNW pfet_05v0 ad=0.3782p pd=1.84u as=0.5368p ps=3.32u w=1.22u l=0.5u
C0 VNW VPW 3.2261f
.ends

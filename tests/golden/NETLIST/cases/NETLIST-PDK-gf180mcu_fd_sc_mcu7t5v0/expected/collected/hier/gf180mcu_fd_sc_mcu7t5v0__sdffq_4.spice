* NGSPICE file created from gf180mcu_fd_sc_mcu7t5v0__sdffq_4.ext - technology: gf180mcuD

.subckt gf180mcu_fd_sc_mcu7t5v0__sdffq_4 D SE SI CLK Q VDD VNW VPW VSS
X0 Q a_3404_428# VSS VPW nfet_05v0 ad=0.2119p pd=1.335u as=0.2119p ps=1.335u w=0.815u l=0.6u
X1 a_2346_502# a_1288_135# a_2132_502# VNW pfet_05v0 ad=0.12285p pd=1.02u as=0.17955p ps=1.2u w=0.63u l=0.5u
X2 VDD a_3404_428# a_3264_502# VNW pfet_05v0 ad=0.42525p pd=1.915u as=0.3375p ps=1.915u w=1.215u l=0.5u
X3 Q a_3404_428# VDD VNW pfet_05v0 ad=0.34627p pd=1.785u as=0.40702p ps=1.885u w=1.215u l=0.5u
X4 Q a_3404_428# VSS VPW nfet_05v0 ad=0.2119p pd=1.335u as=0.3586p ps=2.51u w=0.815u l=0.6u
X5 a_636_156# SE a_468_156# VPW nfet_05v0 ad=93.59999f pd=0.88u as=43.2f ps=0.6u w=0.36u l=0.6u
X6 a_1751_139# a_1288_135# VSS VPW nfet_05v0 ad=0.3519p pd=2.5u as=0.2046p ps=1.81u w=0.465u l=0.6u
X7 a_1751_139# a_1288_135# VDD VNW pfet_05v0 ad=0.3586p pd=2.51u as=0.69407p ps=3.71u w=0.815u l=0.5u
X8 a_2132_502# a_1751_139# a_596_502# VNW pfet_05v0 ad=0.17955p pd=1.2u as=0.2772p ps=2.14u w=0.63u l=0.5u
X9 a_3264_502# a_1751_139# a_3050_502# VNW pfet_05v0 ad=0.3375p pd=1.915u as=0.17955p ps=1.2u w=0.63u l=0.5u
X10 VSS a_2424_386# a_2387_158# VPW nfet_05v0 ad=0.1287p pd=1.075u as=43.2f ps=0.6u w=0.36u l=0.6u
X11 a_3280_158# a_1288_135# a_3050_502# VPW nfet_05v0 ad=0.217p pd=1.515u as=93.59999f ps=0.88u w=0.36u l=0.6u
X12 a_448_502# SI VDD VNW pfet_05v0 ad=75.59999f pd=0.87u as=0.1953p ps=1.25u w=0.63u l=0.5u
X13 a_468_156# SI VSS VPW nfet_05v0 ad=43.2f pd=0.6u as=93.59999f ps=0.88u w=0.36u l=0.6u
X14 a_3404_428# a_3050_502# VSS VPW nfet_05v0 ad=0.3586p pd=2.51u as=0.2119p ps=1.335u w=0.815u l=0.6u
X15 a_596_502# a_36_156# a_448_502# VNW pfet_05v0 ad=0.1638p pd=1.15u as=75.59999f ps=0.87u w=0.63u l=0.5u
X16 a_2424_386# a_2132_502# VDD VNW pfet_05v0 ad=0.2079p pd=1.29u as=0.3294p ps=1.74u w=0.63u l=0.51u
X17 a_3404_428# a_3050_502# VDD VNW pfet_05v0 ad=0.6561p pd=3.51u as=0.42525p ps=1.915u w=1.215u l=0.5u
X18 a_2387_158# a_1751_139# a_2132_502# VPW nfet_05v0 ad=43.2f pd=0.6u as=93.59999f ps=0.88u w=0.36u l=0.6u
X19 VSS D a_860_156# VPW nfet_05v0 ad=0.147p pd=1.165u as=43.2f ps=0.6u w=0.36u l=0.6u
X20 VSS a_3404_428# a_3280_158# VPW nfet_05v0 ad=0.2119p pd=1.335u as=0.217p ps=1.515u w=0.815u l=0.6u
X21 VDD a_2424_386# a_2346_502# VNW pfet_05v0 ad=0.3294p pd=1.74u as=0.12285p ps=1.02u w=0.63u l=0.5u
X22 a_3050_502# a_1288_135# a_2424_386# VNW pfet_05v0 ad=0.17955p pd=1.2u as=0.2079p ps=1.29u w=0.63u l=0.5u
X23 a_2424_386# a_2132_502# VSS VPW nfet_05v0 ad=0.1062p pd=0.95u as=0.1287p ps=1.075u w=0.36u l=0.6u
X24 VDD SE a_36_156# VNW pfet_05v0 ad=0.1953p pd=1.25u as=0.2772p ps=2.14u w=0.63u l=0.5u
X25 a_800_502# SE a_596_502# VNW pfet_05v0 ad=0.1386p pd=1.07u as=0.1638p ps=1.15u w=0.63u l=0.5u
X26 a_860_156# a_36_156# a_636_156# VPW nfet_05v0 ad=43.2f pd=0.6u as=93.59999f ps=0.88u w=0.36u l=0.6u
X27 VSS SE a_36_156# VPW nfet_05v0 ad=93.59999f pd=0.88u as=0.1584p ps=1.6u w=0.36u l=0.6u
X28 VSS a_3404_428# Q VPW nfet_05v0 ad=0.3586p pd=2.51u as=0.2119p ps=1.335u w=0.815u l=0.6u
X29 VDD D a_800_502# VNW pfet_05v0 ad=0.43p pd=1.995u as=0.1386p ps=1.07u w=0.63u l=0.5u
X30 a_1288_135# CLK VSS VPW nfet_05v0 ad=0.3713p pd=2.58u as=0.147p ps=1.165u w=0.465u l=0.6u
X31 VDD a_3404_428# Q VNW pfet_05v0 ad=0.40702p pd=1.885u as=0.34627p ps=1.785u w=1.215u l=0.5u
X32 VSS a_3404_428# Q VPW nfet_05v0 ad=0.2119p pd=1.335u as=0.2119p ps=1.335u w=0.815u l=0.6u
X33 a_2132_502# a_1288_135# a_636_156# VPW nfet_05v0 ad=93.59999f pd=0.88u as=0.1584p ps=1.6u w=0.36u l=0.6u
X34 Q a_3404_428# VDD VNW pfet_05v0 ad=0.34627p pd=1.785u as=0.5346p ps=3.31u w=1.215u l=0.5u
X35 VDD a_3404_428# Q VNW pfet_05v0 ad=0.5346p pd=3.31u as=0.34627p ps=1.785u w=1.215u l=0.5u
X36 a_1288_135# CLK VDD VNW pfet_05v0 ad=0.4048p pd=2.72u as=0.43p ps=1.995u w=0.92u l=0.5u
X37 a_3050_502# a_1751_139# a_2424_386# VPW nfet_05v0 ad=93.59999f pd=0.88u as=0.1062p ps=0.95u w=0.36u l=0.6u
C0 VNW VPW 7.86908f
.ends

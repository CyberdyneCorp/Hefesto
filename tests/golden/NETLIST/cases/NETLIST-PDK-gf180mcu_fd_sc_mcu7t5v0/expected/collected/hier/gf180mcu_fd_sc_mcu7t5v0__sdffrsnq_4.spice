* NGSPICE file created from gf180mcu_fd_sc_mcu7t5v0__sdffrsnq_4.ext - technology: gf180mcuD

.subckt gf180mcu_fd_sc_mcu7t5v0__sdffrsnq_4 D RN SE SETN SI CLK Q VDD VNW VPW VSS
X0 Q a_4234_112# VDD VNW pfet_05v0 ad=0.3172p pd=1.74u as=0.3172p ps=1.74u w=1.22u l=0.5u
X1 a_2404_124# a_1748_497# a_2096_497# VPW nfet_05v0 ad=43.2f pd=0.6u as=93.59999f ps=0.88u w=0.36u l=0.6u
X2 VDD a_4234_112# Q VNW pfet_05v0 ad=0.3172p pd=1.74u as=0.3172p ps=1.74u w=1.22u l=0.5u
X3 a_3079_185# a_2096_497# VSS VPW nfet_05v0 ad=43.2f pd=0.6u as=0.27257p ps=1.76u w=0.36u l=0.6u
X4 VDD a_3471_185# a_4234_112# VNW pfet_05v0 ad=0.3172p pd=1.74u as=0.3416p ps=1.78u w=1.22u l=0.5u
X5 a_636_156# SE a_468_156# VPW nfet_05v0 ad=93.59999f pd=0.88u as=43.2f ps=0.6u w=0.36u l=0.6u
X6 a_1748_497# a_1285_502# VSS VPW nfet_05v0 ad=0.3519p pd=2.5u as=0.2046p ps=1.81u w=0.465u l=0.6u
X7 a_4578_156# RN VSS VPW nfet_05v0 ad=0.218p pd=1.52u as=93.59999f ps=0.88u w=0.36u l=0.6u
X8 a_2336_474# a_1285_502# a_2096_497# VNW pfet_05v0 ad=0.1625p pd=1.145u as=0.2245p ps=1.44u w=0.625u l=0.5u
X9 Q a_4234_112# VDD VNW pfet_05v0 ad=0.3172p pd=1.74u as=0.3172p ps=1.74u w=1.22u l=0.5u
X10 a_3471_185# a_1748_497# a_2440_430# VPW nfet_05v0 ad=94.5f pd=0.885u as=93.59999f ps=0.88u w=0.36u l=0.6u
X11 VSS a_4234_112# Q VPW nfet_05v0 ad=0.3608p pd=2.52u as=0.2132p ps=1.34u w=0.82u l=0.6u
X12 a_2096_497# a_1748_497# a_596_502# VNW pfet_05v0 ad=0.2245p pd=1.44u as=0.275p ps=2.13u w=0.625u l=0.5u
X13 VDD a_2440_430# a_2336_474# VNW pfet_05v0 ad=0.42202p pd=2.33u as=0.1625p ps=1.145u w=0.625u l=0.5u
X14 VDD a_4234_112# Q VNW pfet_05v0 ad=0.5368p pd=3.32u as=0.3172p ps=1.74u w=1.22u l=0.5u
X15 a_448_502# SI VDD VNW pfet_05v0 ad=75.59999f pd=0.87u as=0.1953p ps=1.25u w=0.63u l=0.5u
X16 a_2440_430# SETN VDD VNW pfet_05v0 ad=0.1638p pd=1.15u as=0.41415p ps=2.215u w=0.63u l=0.5u
X17 a_468_156# SI VSS VPW nfet_05v0 ad=43.2f pd=0.6u as=93.59999f ps=0.88u w=0.36u l=0.6u
X18 a_596_502# a_36_156# a_448_502# VNW pfet_05v0 ad=0.2268p pd=1.35u as=75.59999f ps=0.87u w=0.63u l=0.5u
X19 a_2336_474# RN VDD VNW pfet_05v0 ad=0.275p pd=2.13u as=0.42202p ps=2.33u w=0.625u l=0.5u
X20 a_2096_497# a_1285_502# a_636_156# VPW nfet_05v0 ad=93.59999f pd=0.88u as=0.1584p ps=1.6u w=0.36u l=0.6u
X21 a_1285_502# CLK VDD VNW pfet_05v0 ad=0.4995p pd=2.93u as=0.4113p ps=1.91u w=0.925u l=0.5u
X22 a_3471_185# a_1285_502# a_2440_430# VNW pfet_05v0 ad=0.1638p pd=1.15u as=0.1638p ps=1.15u w=0.63u l=0.5u
X23 Q a_4234_112# VSS VPW nfet_05v0 ad=0.2132p pd=1.34u as=0.2132p ps=1.34u w=0.82u l=0.6u
X24 a_3696_185# a_1748_497# a_3471_185# VNW pfet_05v0 ad=0.3024p pd=2.22u as=0.1638p ps=1.15u w=0.63u l=0.5u
X25 VSS a_36_156# a_860_156# VPW nfet_05v0 ad=0.1644p pd=1.25u as=43.2f ps=0.6u w=0.36u l=0.6u
X26 VSS a_4234_112# a_4186_156# VPW nfet_05v0 ad=93.59999f pd=0.88u as=43.2f ps=0.6u w=0.36u l=0.6u
X27 Q a_4234_112# VSS VPW nfet_05v0 ad=0.2132p pd=1.34u as=0.3608p ps=2.52u w=0.82u l=0.6u
X28 VDD a_2096_497# a_2440_430# VNW pfet_05v0 ad=0.41415p pd=2.215u as=0.275p ps=2.13u w=0.625u l=0.5u
X29 a_4234_112# RN VDD VNW pfet_05v0 ad=0.3416p pd=1.78u as=0.3385p ps=1.92u w=1.22u l=0.5u
X30 VSS RN a_2572_124# VPW nfet_05v0 ad=0.27257p pd=1.76u as=43.2f ps=0.6u w=0.36u l=0.6u
X31 a_2440_430# SETN a_3079_185# VPW nfet_05v0 ad=93.59999f pd=0.88u as=43.2f ps=0.6u w=0.36u l=0.6u
X32 a_840_502# D a_596_502# VNW pfet_05v0 ad=75.59999f pd=0.87u as=0.2268p ps=1.35u w=0.63u l=0.5u
X33 VDD SE a_36_156# VNW pfet_05v0 ad=0.1953p pd=1.25u as=0.2772p ps=2.14u w=0.63u l=0.5u
X34 a_860_156# D a_636_156# VPW nfet_05v0 ad=43.2f pd=0.6u as=93.59999f ps=0.88u w=0.36u l=0.6u
X35 a_1748_497# a_1285_502# VDD VNW pfet_05v0 ad=0.3586p pd=2.51u as=0.6621p ps=3.64u w=0.815u l=0.5u
X36 VSS SE a_36_156# VPW nfet_05v0 ad=93.59999f pd=0.88u as=0.1584p ps=1.6u w=0.36u l=0.6u
X37 a_1285_502# CLK VSS VPW nfet_05v0 ad=0.3591p pd=2.54u as=0.1644p ps=1.25u w=0.465u l=0.6u
X38 a_4186_156# SETN a_3696_185# VPW nfet_05v0 ad=43.2f pd=0.6u as=0.1584p ps=1.6u w=0.36u l=0.6u
X39 VDD SE a_840_502# VNW pfet_05v0 ad=0.4113p pd=1.91u as=75.59999f ps=0.87u w=0.63u l=0.5u
X40 a_4234_112# a_3471_185# a_4578_156# VPW nfet_05v0 ad=0.3608p pd=2.52u as=0.218p ps=1.52u w=0.82u l=0.6u
X41 VSS a_4234_112# Q VPW nfet_05v0 ad=0.2132p pd=1.34u as=0.2132p ps=1.34u w=0.82u l=0.6u
X42 a_2572_124# a_2440_430# a_2404_124# VPW nfet_05v0 ad=43.2f pd=0.6u as=43.2f ps=0.6u w=0.36u l=0.6u
X43 a_3696_185# SETN VDD VNW pfet_05v0 ad=0.1638p pd=1.15u as=0.2772p ps=2.14u w=0.63u l=0.5u
X44 VDD a_4234_112# a_3696_185# VNW pfet_05v0 ad=0.3385p pd=1.92u as=0.1638p ps=1.15u w=0.63u l=0.5u
X45 a_3696_185# a_1285_502# a_3471_185# VPW nfet_05v0 ad=0.1584p pd=1.6u as=94.5f ps=0.885u w=0.36u l=0.6u
C0 VNW VPW 9.52526f
.ends

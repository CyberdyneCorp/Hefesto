* SPICE3 file created from top.ext - technology: nltest

.option scale=10n

.global VDD GND

* Black-box entry subcircuit for sram abstract view
.subckt sram A D
.ends

.subckt inv in out
M1000 out in gnd gnd nfet w=4 l=2
+  ad=40p pd=26u as=20p ps=18u
M1001 out in vdd vdd pfet w=8 l=2
+  ad=0 pd=0 as=40p ps=26u
.ends

* Top level circuit top

Xs1 n s1/D sram
Xp1 p1/p prim m=1
Xi1 n i1/out inv
.end

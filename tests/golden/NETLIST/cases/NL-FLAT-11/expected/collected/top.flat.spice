* SPICE3 file created from top.ext - technology: nltest

.option scale=10n

M1000 u1/out u1/in u1/out GND nfet w=4 l=2
+  ad=0 pd=0 as=0 ps=0
M1001 u2/out u2/in u2/out GND nfet w=4 l=2
+  ad=0 pd=0 as=0 ps=0
M1002 u3/out u3/in u3/out GND nfet w=4 l=2
+  ad=0 pd=0 as=0 ps=0
M1003 ua/out ua/in ua/out GND nfet w=4 l=2
+  ad=0 pd=0 as=0 ps=0
M1004 b10/out b10/in b10/out GND nfet w=4 l=2
+  ad=0 pd=0 as=0 ps=0

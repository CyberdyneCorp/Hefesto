* SPICE3 file created from top.ext - technology: nltest

.option scale=10n

.global VDD GND

.subckt inv in out
M1000 out in gnd gnd nfet w=4 l=2
+  ad=40p pd=26u as=20p ps=18u
M1001 out in vdd vdd pfet w=8 l=2
+  ad=0 pd=0 as=40p ps=26u
.ends

* Top level circuit top

Xr[0] n r[0]/out inv
Xr[1] r[1]/in r[1]/out inv
Xr[2] r[2]/in r[2]/out inv
Xa2[0|0] n a2[0|0]/out inv
Xa2[1|0] a2[1|0]/in a2[1|0]/out inv
Xa2[0|1] a2[0|1]/in a2[0|1]/out inv
Xa2[1|1] a2[1|1]/in a2[1|1]/out inv
.end

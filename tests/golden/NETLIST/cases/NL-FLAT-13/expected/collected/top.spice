* SPICE3 file created from top.ext - technology: nltest

.option scale=10n

M1000 a a a GND nfet w=4 l=2
+  ad=0 pd=0 as=0 ps=0
C0 a 0 1f **FLOATING

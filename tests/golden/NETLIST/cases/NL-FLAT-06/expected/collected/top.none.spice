* SPICE3 file created from top.ext - technology: nltest

.option scale=10n

M1000 g g B GND nfet w=4 l=2
+  ad=0 pd=0 as=0 ps=0
M1001 g g B GND nfet w=4 l=2
+  ad=0 pd=0 as=0 ps=0
C0 B 0 4f

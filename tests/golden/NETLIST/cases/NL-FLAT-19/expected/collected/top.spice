* SPICE3 file created from top.ext - technology: nltest

.option scale=10n

M1000 c1/x c1/x c1/x GND nfet w=4 l=2
+  ad=20p pd=18u as=0 ps=0
M1001 c1/x p p GND nfet w=4 l=2
+  ad=0 pd=0 as=0 ps=0
C0 p 0 1f **FLOATING
C1 c1/x 0 2f **FLOATING

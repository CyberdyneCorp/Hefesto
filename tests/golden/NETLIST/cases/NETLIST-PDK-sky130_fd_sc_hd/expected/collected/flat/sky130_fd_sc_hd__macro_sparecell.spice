* NGSPICE file created from sky130_fd_sc_hd__macro_sparecell.ext - technology: sky130A

X0 VPWR LO sky130_fd_sc_hd__nor2_2_0/B VPB sky130_fd_pr__pfet_01v8_hvt ad=0.26 pd=2.52 as=0.135 ps=1.27 w=1 l=0.15
X1 sky130_fd_sc_hd__nor2_2_0/B LO VPWR VPB sky130_fd_pr__pfet_01v8_hvt ad=0.135 pd=1.27 as=0.135 ps=1.27 w=1 l=0.15
X2 VPWR LO sky130_fd_sc_hd__nor2_2_0/B VPB sky130_fd_pr__pfet_01v8_hvt ad=0.135 pd=1.27 as=0.135 ps=1.27 w=1 l=0.15
X3 sky130_fd_sc_hd__nand2_2_0/a_27_47# LO VGND VNB sky130_fd_pr__nfet_01v8 ad=0.08775 pd=0.92 as=0.08775 ps=0.92 w=0.65 l=0.15
X4 sky130_fd_sc_hd__nand2_2_0/a_27_47# LO sky130_fd_sc_hd__nor2_2_0/B VNB sky130_fd_pr__nfet_01v8 ad=0.169 pd=1.82 as=0.08775 ps=0.92 w=0.65 l=0.15
X5 sky130_fd_sc_hd__nor2_2_0/B LO sky130_fd_sc_hd__nand2_2_0/a_27_47# VNB sky130_fd_pr__nfet_01v8 ad=0.08775 pd=0.92 as=0.08775 ps=0.92 w=0.65 l=0.15
X6 sky130_fd_sc_hd__nor2_2_0/B LO VPWR VPB sky130_fd_pr__pfet_01v8_hvt ad=0.135 pd=1.27 as=0.26 ps=2.52 w=1 l=0.15
X7 VGND LO sky130_fd_sc_hd__nand2_2_0/a_27_47# VNB sky130_fd_pr__nfet_01v8 ad=0.08775 pd=0.92 as=0.169 ps=1.82 w=0.65 l=0.15
X8 VPWR LO sky130_fd_sc_hd__nor2_2_1/B VPB sky130_fd_pr__pfet_01v8_hvt ad=3.16 pd=30.32 as=0.54 ps=5.08 w=1 l=0.15
X9 sky130_fd_sc_hd__nor2_2_1/B LO VPWR VPB sky130_fd_pr__pfet_01v8_hvt ad=0 pd=0 as=0 ps=0 w=1 l=0.15
X10 VPWR LO sky130_fd_sc_hd__nor2_2_1/B VPB sky130_fd_pr__pfet_01v8_hvt ad=0 pd=0 as=0 ps=0 w=1 l=0.15
X11 sky130_fd_sc_hd__nand2_2_1/a_27_47# LO VGND VNB sky130_fd_pr__nfet_01v8 ad=0.5135 pd=5.48 as=2.08 ps=22 w=0.65 l=0.15
X12 sky130_fd_sc_hd__nand2_2_1/a_27_47# LO sky130_fd_sc_hd__nor2_2_1/B VNB sky130_fd_pr__nfet_01v8 ad=0 pd=0 as=0.1755 ps=1.84 w=0.65 l=0.15
X13 sky130_fd_sc_hd__nor2_2_1/B LO sky130_fd_sc_hd__nand2_2_1/a_27_47# VNB sky130_fd_pr__nfet_01v8 ad=0 pd=0 as=0 ps=0 w=0.65 l=0.15
X14 sky130_fd_sc_hd__nor2_2_1/B LO VPWR VPB sky130_fd_pr__pfet_01v8_hvt ad=0 pd=0 as=0 ps=0 w=1 l=0.15
X15 VGND LO sky130_fd_sc_hd__nand2_2_1/a_27_47# VNB sky130_fd_pr__nfet_01v8 ad=0 pd=0 as=0 ps=0 w=0.65 l=0.15
X16 sky130_fd_sc_hd__inv_2_0/Y sky130_fd_sc_hd__inv_2_0/A VPWR VPB sky130_fd_pr__pfet_01v8_hvt ad=0.135 pd=1.27 as=0.26 ps=2.52 w=1 l=0.15
X17 VGND sky130_fd_sc_hd__inv_2_0/A sky130_fd_sc_hd__inv_2_0/Y VNB sky130_fd_pr__nfet_01v8 ad=0.169 pd=1.82 as=0.08775 ps=0.92 w=0.65 l=0.15
X18 sky130_fd_sc_hd__inv_2_0/Y sky130_fd_sc_hd__inv_2_0/A VGND VNB sky130_fd_pr__nfet_01v8 ad=0.08775 pd=0.92 as=0.169 ps=1.82 w=0.65 l=0.15
X19 VPWR sky130_fd_sc_hd__inv_2_0/A sky130_fd_sc_hd__inv_2_0/Y VPB sky130_fd_pr__pfet_01v8_hvt ad=0.26 pd=2.52 as=0.135 ps=1.27 w=1 l=0.15
X20 sky130_fd_sc_hd__inv_2_1/Y sky130_fd_sc_hd__inv_2_1/A VPWR VPB sky130_fd_pr__pfet_01v8_hvt ad=0.27 pd=2.54 as=0 ps=0 w=1 l=0.15
X21 VGND sky130_fd_sc_hd__inv_2_1/A sky130_fd_sc_hd__inv_2_1/Y VNB sky130_fd_pr__nfet_01v8 ad=0 pd=0 as=0.1755 ps=1.84 w=0.65 l=0.15
X22 sky130_fd_sc_hd__inv_2_1/Y sky130_fd_sc_hd__inv_2_1/A VGND VNB sky130_fd_pr__nfet_01v8 ad=0 pd=0 as=0 ps=0 w=0.65 l=0.15
X23 VPWR sky130_fd_sc_hd__inv_2_1/A sky130_fd_sc_hd__inv_2_1/Y VPB sky130_fd_pr__pfet_01v8_hvt ad=0 pd=0 as=0 ps=0 w=1 l=0.15
X24 sky130_fd_sc_hd__inv_2_0/A sky130_fd_sc_hd__nor2_2_0/B sky130_fd_sc_hd__nor2_2_0/a_27_297# VPB sky130_fd_pr__pfet_01v8_hvt ad=0.135 pd=1.27 as=0.135 ps=1.27 w=1 l=0.15
X25 sky130_fd_sc_hd__inv_2_0/A sky130_fd_sc_hd__nor2_2_0/B VGND VNB sky130_fd_pr__nfet_01v8 ad=0.08775 pd=0.92 as=0.08775 ps=0.92 w=0.65 l=0.15
X26 sky130_fd_sc_hd__nor2_2_0/a_27_297# sky130_fd_sc_hd__nor2_2_0/B VPWR VPB sky130_fd_pr__pfet_01v8_hvt ad=0.135 pd=1.27 as=0.135 ps=1.27 w=1 l=0.15
X27 VGND sky130_fd_sc_hd__nor2_2_0/B sky130_fd_sc_hd__inv_2_0/A VNB sky130_fd_pr__nfet_01v8 ad=0.08775 pd=0.92 as=0.08775 ps=0.92 w=0.65 l=0.15
X28 sky130_fd_sc_hd__inv_2_0/A sky130_fd_sc_hd__nor2_2_0/B VGND VNB sky130_fd_pr__nfet_01v8 ad=0.08775 pd=0.92 as=0.182 ps=1.86 w=0.65 l=0.15
X29 VGND sky130_fd_sc_hd__nor2_2_0/B sky130_fd_sc_hd__inv_2_0/A VNB sky130_fd_pr__nfet_01v8 ad=0.169 pd=1.82 as=0.08775 ps=0.92 w=0.65 l=0.15
X30 VPWR sky130_fd_sc_hd__nor2_2_0/B sky130_fd_sc_hd__nor2_2_0/a_27_297# VPB sky130_fd_pr__pfet_01v8_hvt ad=0.135 pd=1.27 as=0.28 ps=2.56 w=1 l=0.15
X31 sky130_fd_sc_hd__nor2_2_0/a_27_297# sky130_fd_sc_hd__nor2_2_0/B sky130_fd_sc_hd__inv_2_0/A VPB sky130_fd_pr__pfet_01v8_hvt ad=0.26 pd=2.52 as=0.135 ps=1.27 w=1 l=0.15
X32 sky130_fd_sc_hd__inv_2_1/A sky130_fd_sc_hd__nor2_2_1/B sky130_fd_sc_hd__nor2_2_1/a_27_297# VPB sky130_fd_pr__pfet_01v8_hvt ad=0.27 pd=2.54 as=0.81 ps=7.62 w=1 l=0.15
X33 sky130_fd_sc_hd__inv_2_1/A sky130_fd_sc_hd__nor2_2_1/B VGND VNB sky130_fd_pr__nfet_01v8 ad=0.351 pd=3.68 as=0 ps=0 w=0.65 l=0.15
X34 sky130_fd_sc_hd__nor2_2_1/a_27_297# sky130_fd_sc_hd__nor2_2_1/B VPWR VPB sky130_fd_pr__pfet_01v8_hvt ad=0 pd=0 as=0 ps=0 w=1 l=0.15
X35 VGND sky130_fd_sc_hd__nor2_2_1/B sky130_fd_sc_hd__inv_2_1/A VNB sky130_fd_pr__nfet_01v8 ad=0 pd=0 as=0 ps=0 w=0.65 l=0.15
X36 sky130_fd_sc_hd__inv_2_1/A sky130_fd_sc_hd__nor2_2_1/B VGND VNB sky130_fd_pr__nfet_01v8 ad=0 pd=0 as=0 ps=0 w=0.65 l=0.15
X37 VGND sky130_fd_sc_hd__nor2_2_1/B sky130_fd_sc_hd__inv_2_1/A VNB sky130_fd_pr__nfet_01v8 ad=0 pd=0 as=0 ps=0 w=0.65 l=0.15
X38 VPWR sky130_fd_sc_hd__nor2_2_1/B sky130_fd_sc_hd__nor2_2_1/a_27_297# VPB sky130_fd_pr__pfet_01v8_hvt ad=0 pd=0 as=0 ps=0 w=1 l=0.15
X39 sky130_fd_sc_hd__nor2_2_1/a_27_297# sky130_fd_sc_hd__nor2_2_1/B sky130_fd_sc_hd__inv_2_1/A VPB sky130_fd_pr__pfet_01v8_hvt ad=0 pd=0 as=0 ps=0 w=1 l=0.15
X40 VPWR sky130_fd_sc_hd__conb_1_0/HI sky130_fd_pr__res_generic_po w=0.48 l=0.5
X41 LO VGND sky130_fd_pr__res_generic_po w=0.48 l=0.5

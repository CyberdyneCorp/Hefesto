* NGSPICE file created from sky130_fd_sc_hd__fa_4.ext - technology: sky130A

.subckt sky130_fd_sc_hd__fa_4 A B CIN VGND VNB VPB VPWR COUT SUM
X0 a_1014_369# B VPWR VPB sky130_fd_pr__pfet_01v8_hvt ad=0.0864 pd=0.91 as=0.1664 ps=1.8 w=0.64 l=0.15
X1 VPWR CIN a_1014_369# VPB sky130_fd_pr__pfet_01v8_hvt ad=0.0864 pd=0.91 as=0.0864 ps=0.91 w=0.64 l=0.15
X2 VPWR A a_658_369# VPB sky130_fd_pr__pfet_01v8_hvt ad=0.0864 pd=0.91 as=0.0864 ps=0.91 w=0.64 l=0.15
X3 VGND A a_658_47# VNB sky130_fd_pr__nfet_01v8 ad=0.0567 pd=0.69 as=0.0567 ps=0.69 w=0.42 l=0.15
X4 a_79_21# B a_456_371# VPB sky130_fd_pr__pfet_01v8_hvt ad=0.1322 pd=1.055 as=0.09292 ps=0.925 w=0.63 l=0.15
X5 a_658_369# CIN a_79_21# VPB sky130_fd_pr__pfet_01v8_hvt ad=0.0864 pd=0.91 as=0.1322 ps=1.055 w=0.64 l=0.15
X6 VPWR a_1271_47# SUM VPB sky130_fd_pr__pfet_01v8_hvt ad=0.175 pd=1.35 as=0.135 ps=1.27 w=1 l=0.15
X7 a_461_47# A VGND VNB sky130_fd_pr__nfet_01v8 ad=0.06825 pd=0.745 as=0.1034 ps=1 w=0.42 l=0.15
X8 VPWR a_79_21# COUT VPB sky130_fd_pr__pfet_01v8_hvt ad=0.14863 pd=1.325 as=0.135 ps=1.27 w=1 l=0.15
X9 SUM a_1271_47# VPWR VPB sky130_fd_pr__pfet_01v8_hvt ad=0.135 pd=1.27 as=0.14863 ps=1.325 w=1 l=0.15
X10 a_1271_47# a_79_21# a_1014_47# VNB sky130_fd_pr__nfet_01v8 ad=0.0819 pd=0.81 as=0.06195 ps=0.715 w=0.42 l=0.15
X11 a_658_47# CIN a_79_21# VNB sky130_fd_pr__nfet_01v8 ad=0.0567 pd=0.69 as=0.0756 ps=0.78 w=0.42 l=0.15
X12 a_658_47# B VGND VNB sky130_fd_pr__nfet_01v8 ad=0.1092 pd=1.36 as=0.0567 ps=0.69 w=0.42 l=0.15
X13 COUT a_79_21# VPWR VPB sky130_fd_pr__pfet_01v8_hvt ad=0.135 pd=1.27 as=0.135 ps=1.27 w=1 l=0.15
X14 a_456_371# A VPWR VPB sky130_fd_pr__pfet_01v8_hvt ad=0.09292 pd=0.925 as=0.14863 ps=1.325 w=0.63 l=0.15
X15 a_1451_47# B a_1379_47# VNB sky130_fd_pr__nfet_01v8 ad=0.0693 pd=0.75 as=0.0441 ps=0.63 w=0.42 l=0.15
X16 VPWR a_79_21# COUT VPB sky130_fd_pr__pfet_01v8_hvt ad=0.135 pd=1.27 as=0.135 ps=1.27 w=1 l=0.15
X17 VGND a_79_21# COUT VNB sky130_fd_pr__nfet_01v8 ad=0.08775 pd=0.92 as=0.08775 ps=0.92 w=0.65 l=0.15
X18 VGND a_79_21# COUT VNB sky130_fd_pr__nfet_01v8 ad=0.1034 pd=1 as=0.08775 ps=0.92 w=0.65 l=0.15
X19 VPWR a_1271_47# SUM VPB sky130_fd_pr__pfet_01v8_hvt ad=0.295 pd=2.59 as=0.135 ps=1.27 w=1 l=0.15
X20 VGND a_1271_47# SUM VNB sky130_fd_pr__nfet_01v8 ad=0.08775 pd=0.92 as=0.11375 ps=1 w=0.65 l=0.15
X21 VGND a_1271_47# SUM VNB sky130_fd_pr__nfet_01v8 ad=0.1885 pd=1.88 as=0.08775 ps=0.92 w=0.65 l=0.15
X22 a_1451_371# B a_1356_369# VPB sky130_fd_pr__pfet_01v8_hvt ad=0.12285 pd=1.02 as=0.10362 ps=0.965 w=0.63 l=0.15
X23 a_79_21# B a_461_47# VNB sky130_fd_pr__nfet_01v8 ad=0.0756 pd=0.78 as=0.06825 ps=0.745 w=0.42 l=0.15
X24 a_1014_47# A VGND VNB sky130_fd_pr__nfet_01v8 ad=0.06195 pd=0.715 as=0.0567 ps=0.69 w=0.42 l=0.15
X25 a_1271_47# a_79_21# a_1014_369# VPB sky130_fd_pr__pfet_01v8_hvt ad=0.088 pd=0.915 as=0.0944 ps=0.935 w=0.64 l=0.15
X26 COUT a_79_21# VGND VNB sky130_fd_pr__nfet_01v8 ad=0.08775 pd=0.92 as=0.08775 ps=0.92 w=0.65 l=0.15
X27 a_658_369# B VPWR VPB sky130_fd_pr__pfet_01v8_hvt ad=0.1664 pd=1.8 as=0.0864 ps=0.91 w=0.64 l=0.15
X28 VPWR A a_1451_371# VPB sky130_fd_pr__pfet_01v8_hvt ad=0.14863 pd=1.325 as=0.12285 ps=1.02 w=0.63 l=0.15
X29 a_1014_47# B VGND VNB sky130_fd_pr__nfet_01v8 ad=0.0567 pd=0.69 as=0.1092 ps=1.36 w=0.42 l=0.15
X30 a_1379_47# CIN a_1271_47# VNB sky130_fd_pr__nfet_01v8 ad=0.0441 pd=0.63 as=0.0819 ps=0.81 w=0.42 l=0.15
X31 VGND A a_1451_47# VNB sky130_fd_pr__nfet_01v8 ad=0.11535 pd=1.035 as=0.0693 ps=0.75 w=0.42 l=0.15
X32 SUM a_1271_47# VGND VNB sky130_fd_pr__nfet_01v8 ad=0.08775 pd=0.92 as=0.08775 ps=0.92 w=0.65 l=0.15
X33 a_1356_369# CIN a_1271_47# VPB sky130_fd_pr__pfet_01v8_hvt ad=0.10362 pd=0.965 as=0.088 ps=0.915 w=0.64 l=0.15
X34 SUM a_1271_47# VGND VNB sky130_fd_pr__nfet_01v8 ad=0.11375 pd=1 as=0.11535 ps=1.035 w=0.65 l=0.15
X35 SUM a_1271_47# VPWR VPB sky130_fd_pr__pfet_01v8_hvt ad=0.135 pd=1.27 as=0.175 ps=1.35 w=1 l=0.15
X36 VGND CIN a_1014_47# VNB sky130_fd_pr__nfet_01v8 ad=0.0567 pd=0.69 as=0.0567 ps=0.69 w=0.42 l=0.15
X37 a_1014_369# A VPWR VPB sky130_fd_pr__pfet_01v8_hvt ad=0.0944 pd=0.935 as=0.0864 ps=0.91 w=0.64 l=0.15
X38 COUT a_79_21# VPWR VPB sky130_fd_pr__pfet_01v8_hvt ad=0.135 pd=1.27 as=0.26 ps=2.52 w=1 l=0.15
X39 COUT a_79_21# VGND VNB sky130_fd_pr__nfet_01v8 ad=0.08775 pd=0.92 as=0.169 ps=1.82 w=0.65 l=0.15
C0 VPB VNB 2.0223f
.ends

* NGSPICE file created from sky130_fd_sc_hd__sdfbbn_1.ext - technology: sky130A

.subckt sky130_fd_sc_hd__sdfbbn_1 CLK_N D RESET_B SCD SCE SET_B VGND VNB VPB VPWR
+ Q Q_N
X0 a_381_363# SCD VPWR VPB sky130_fd_pr__pfet_01v8_hvt ad=0.0672 pd=0.85 as=0.1664 ps=1.8 w=0.64 l=0.15
X1 a_1102_21# SET_B VPWR VPB sky130_fd_pr__pfet_01v8_hvt ad=0.147 pd=1.23 as=0.0798 ps=0.8 w=0.42 l=0.15
X2 VPWR a_1396_21# a_2122_329# VPB sky130_fd_pr__pfet_01v8_hvt ad=0.2184 pd=2.2 as=0.0882 ps=1.05 w=0.84 l=0.15
X3 Q a_2596_47# VPWR VPB sky130_fd_pr__pfet_01v8_hvt ad=0.26 pd=2.52 as=0.149 ps=1.325 w=1 l=0.15
X4 a_917_47# a_27_47# a_453_47# VPB sky130_fd_pr__pfet_01v8_hvt ad=0.0567 pd=0.69 as=0.07035 ps=0.755 w=0.42 l=0.15
X5 VPWR a_1396_21# a_1351_329# VPB sky130_fd_pr__pfet_01v8_hvt ad=0.2247 pd=1.375 as=0.1134 ps=1.11 w=0.84 l=0.15
X6 VPWR SCE a_423_315# VPB sky130_fd_pr__pfet_01v8_hvt ad=0.0567 pd=0.69 as=0.1092 ps=1.36 w=0.42 l=0.15
X7 VGND SCE a_423_315# VNB sky130_fd_pr__nfet_01v8 ad=0.05985 pd=0.705 as=0.1092 ps=1.36 w=0.42 l=0.15
X8 a_1614_47# a_1102_21# VGND VNB sky130_fd_pr__nfet_01v8 ad=0.098 pd=0.99 as=0.1664 ps=1.8 w=0.64 l=0.15
X9 a_1351_329# a_917_47# a_1102_21# VPB sky130_fd_pr__pfet_01v8_hvt ad=0.1134 pd=1.11 as=0.147 ps=1.23 w=0.84 l=0.15
X10 a_1030_47# a_27_47# a_917_47# VNB sky130_fd_pr__special_nfet_01v8 ad=0.07335 pd=0.78 as=0.0747 ps=0.775 w=0.36 l=0.15
X11 VPWR RESET_B a_1396_21# VPB sky130_fd_pr__pfet_01v8_hvt ad=0.1539 pd=1.335 as=0.1664 ps=1.8 w=0.64 l=0.15
X12 VPWR CLK_N a_27_47# VPB sky130_fd_pr__pfet_01v8_hvt ad=0.0864 pd=0.91 as=0.1664 ps=1.8 w=0.64 l=0.15
X13 a_1572_329# a_1102_21# VPWR VPB sky130_fd_pr__pfet_01v8_hvt ad=0.1743 pd=1.41 as=0.2247 ps=1.375 w=0.84 l=0.15
X14 a_2122_329# a_1714_47# a_1887_21# VPB sky130_fd_pr__pfet_01v8_hvt ad=0.0882 pd=1.05 as=0.12285 ps=1.17 w=0.84 l=0.15
X15 VGND a_1887_21# a_1822_47# VNB sky130_fd_pr__nfet_01v8 ad=0.05985 pd=0.705 as=0.066 ps=0.745 w=0.42 l=0.15
X16 VPWR a_1102_21# a_1017_413# VPB sky130_fd_pr__pfet_01v8_hvt ad=0.0798 pd=0.8 as=0.0945 ps=0.87 w=0.42 l=0.15
X17 VPWR a_1887_21# a_1800_413# VPB sky130_fd_pr__pfet_01v8_hvt ad=0.0819 pd=0.81 as=0.0924 ps=0.86 w=0.42 l=0.15
X18 a_1887_21# a_1714_47# a_2004_47# VNB sky130_fd_pr__nfet_01v8 ad=0.0864 pd=0.91 as=0.11885 ps=1.075 w=0.64 l=0.15
X19 a_1887_21# SET_B VPWR VPB sky130_fd_pr__pfet_01v8_hvt ad=0.12285 pd=1.17 as=0.0819 ps=0.81 w=0.42 l=0.15
X20 a_1800_413# a_27_47# a_1714_47# VPB sky130_fd_pr__pfet_01v8_hvt ad=0.0924 pd=0.86 as=0.0567 ps=0.69 w=0.42 l=0.15
X21 a_1102_21# a_917_47# a_1241_47# VNB sky130_fd_pr__nfet_01v8 ad=0.0864 pd=0.91 as=0.10205 ps=0.995 w=0.64 l=0.15
X22 a_193_47# a_27_47# VGND VNB sky130_fd_pr__nfet_01v8 ad=0.1092 pd=1.36 as=0.0567 ps=0.69 w=0.42 l=0.15
X23 a_453_47# D a_735_47# VNB sky130_fd_pr__nfet_01v8 ad=0.066 pd=0.745 as=0.05985 ps=0.705 w=0.42 l=0.15
X24 a_1714_47# a_193_47# a_1572_329# VPB sky130_fd_pr__pfet_01v8_hvt ad=0.0567 pd=0.69 as=0.1743 ps=1.41 w=0.42 l=0.15
X25 a_2004_47# a_1396_21# a_1887_21# VNB sky130_fd_pr__nfet_01v8 ad=0.1664 pd=1.8 as=0.0864 ps=0.91 w=0.64 l=0.15
X26 Q a_2596_47# VGND VNB sky130_fd_pr__nfet_01v8 ad=0.169 pd=1.82 as=0.097 ps=0.975 w=0.65 l=0.15
X27 VGND a_1887_21# a_2596_47# VNB sky130_fd_pr__nfet_01v8 ad=0.097 pd=0.975 as=0.1092 ps=1.36 w=0.42 l=0.15
X28 a_193_47# a_27_47# VPWR VPB sky130_fd_pr__pfet_01v8_hvt ad=0.1664 pd=1.8 as=0.0864 ps=0.91 w=0.64 l=0.15
X29 a_1241_47# SET_B VGND VNB sky130_fd_pr__nfet_01v8 ad=0.10205 pd=0.995 as=0.08295 ps=0.815 w=0.42 l=0.15
X30 a_1241_47# a_1396_21# a_1102_21# VNB sky130_fd_pr__nfet_01v8 ad=0.1664 pd=1.8 as=0.0864 ps=0.91 w=0.64 l=0.15
X31 a_1017_413# a_193_47# a_917_47# VPB sky130_fd_pr__pfet_01v8_hvt ad=0.0945 pd=0.87 as=0.0567 ps=0.69 w=0.42 l=0.15
X32 VGND a_1102_21# a_1030_47# VNB sky130_fd_pr__nfet_01v8 ad=0.08295 pd=0.815 as=0.07335 ps=0.78 w=0.42 l=0.15
X33 a_735_47# a_423_315# VGND VNB sky130_fd_pr__nfet_01v8 ad=0.05985 pd=0.705 as=0.05985 ps=0.705 w=0.42 l=0.15
X34 VPWR a_1887_21# a_2596_47# VPB sky130_fd_pr__pfet_01v8_hvt ad=0.149 pd=1.325 as=0.1664 ps=1.8 w=0.64 l=0.15
X35 a_453_47# a_423_315# a_381_363# VPB sky130_fd_pr__pfet_01v8_hvt ad=0.1664 pd=1.8 as=0.0672 ps=0.85 w=0.64 l=0.15
X36 a_381_47# SCD VGND VNB sky130_fd_pr__nfet_01v8 ad=0.0441 pd=0.63 as=0.1092 ps=1.36 w=0.42 l=0.15
X37 a_1822_47# a_193_47# a_1714_47# VNB sky130_fd_pr__special_nfet_01v8 ad=0.066 pd=0.745 as=0.0702 ps=0.75 w=0.36 l=0.15
X38 Q_N a_1887_21# VGND VNB sky130_fd_pr__nfet_01v8 ad=0.169 pd=1.82 as=0.10025 ps=0.985 w=0.65 l=0.15
X39 Q_N a_1887_21# VPWR VPB sky130_fd_pr__pfet_01v8_hvt ad=0.26 pd=2.52 as=0.1539 ps=1.335 w=1 l=0.15
X40 a_1714_47# a_27_47# a_1614_47# VNB sky130_fd_pr__special_nfet_01v8 ad=0.0702 pd=0.75 as=0.098 ps=0.99 w=0.36 l=0.15
X41 a_453_47# D a_752_413# VPB sky130_fd_pr__pfet_01v8_hvt ad=0.07035 pd=0.755 as=0.0567 ps=0.69 w=0.42 l=0.15
X42 a_917_47# a_193_47# a_453_47# VNB sky130_fd_pr__special_nfet_01v8 ad=0.0747 pd=0.775 as=0.066 ps=0.745 w=0.36 l=0.15
X43 a_2004_47# SET_B VGND VNB sky130_fd_pr__nfet_01v8 ad=0.11885 pd=1.075 as=0.05985 ps=0.705 w=0.42 l=0.15
X44 a_752_413# SCE VPWR VPB sky130_fd_pr__pfet_01v8_hvt ad=0.0567 pd=0.69 as=0.0567 ps=0.69 w=0.42 l=0.15
X45 VGND CLK_N a_27_47# VNB sky130_fd_pr__nfet_01v8 ad=0.0567 pd=0.69 as=0.1092 ps=1.36 w=0.42 l=0.15
X46 a_453_47# SCE a_381_47# VNB sky130_fd_pr__nfet_01v8 ad=0.1239 pd=1.43 as=0.0441 ps=0.63 w=0.42 l=0.15
X47 VGND RESET_B a_1396_21# VNB sky130_fd_pr__nfet_01v8 ad=0.10025 pd=0.985 as=0.1092 ps=1.36 w=0.42 l=0.15
C0 VPB VNB 2.81966f
.ends

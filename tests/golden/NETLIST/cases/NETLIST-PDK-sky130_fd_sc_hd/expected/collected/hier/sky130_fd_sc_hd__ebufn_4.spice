* NGSPICE file created from sky130_fd_sc_hd__ebufn_4.ext - technology: sky130A

.subckt sky130_fd_sc_hd__ebufn_4 A TE_B VGND VNB VPB VPWR Z
X0 a_214_47# TE_B VPWR VPB sky130_fd_pr__pfet_01v8_hvt ad=0.26 pd=2.52 as=0.1875 ps=1.375 w=1 l=0.15
X1 Z a_27_47# a_320_309# VPB sky130_fd_pr__pfet_01v8_hvt ad=0.135 pd=1.27 as=0.37525 ps=1.755 w=1 l=0.15
X2 VGND a_214_47# a_393_47# VNB sky130_fd_pr__nfet_01v8 ad=0.08775 pd=0.92 as=0.169 ps=1.82 w=0.65 l=0.15
X3 a_320_309# TE_B VPWR VPB sky130_fd_pr__pfet_01v8_hvt ad=0.37525 pd=1.755 as=0.1269 ps=1.21 w=0.94 l=0.15
X4 VGND a_214_47# a_393_47# VNB sky130_fd_pr__nfet_01v8 ad=0.08775 pd=0.92 as=0.08775 ps=0.92 w=0.65 l=0.15
X5 VPWR TE_B a_320_309# VPB sky130_fd_pr__pfet_01v8_hvt ad=0.1269 pd=1.21 as=0.1269 ps=1.21 w=0.94 l=0.15
X6 a_320_309# TE_B VPWR VPB sky130_fd_pr__pfet_01v8_hvt ad=0.1269 pd=1.21 as=0.1269 ps=1.21 w=0.94 l=0.15
X7 a_393_47# a_214_47# VGND VNB sky130_fd_pr__nfet_01v8 ad=0.08775 pd=0.92 as=0.08775 ps=0.92 w=0.65 l=0.15
X8 Z a_27_47# a_393_47# VNB sky130_fd_pr__nfet_01v8 ad=0.08775 pd=0.92 as=0.12675 ps=1.04 w=0.65 l=0.15
X9 VPWR TE_B a_320_309# VPB sky130_fd_pr__pfet_01v8_hvt ad=0.1269 pd=1.21 as=0.2444 ps=2.4 w=0.94 l=0.15
X10 a_393_47# a_214_47# VGND VNB sky130_fd_pr__nfet_01v8 ad=0.12675 pd=1.04 as=0.08775 ps=0.92 w=0.65 l=0.15
X11 Z a_27_47# a_393_47# VNB sky130_fd_pr__nfet_01v8 ad=0.08775 pd=0.92 as=0.08775 ps=0.92 w=0.65 l=0.15
X12 a_393_47# a_27_47# Z VNB sky130_fd_pr__nfet_01v8 ad=0.182 pd=1.86 as=0.08775 ps=0.92 w=0.65 l=0.15
X13 a_214_47# TE_B VGND VNB sky130_fd_pr__nfet_01v8 ad=0.169 pd=1.82 as=0.12188 ps=1.025 w=0.65 l=0.15
X14 Z a_27_47# a_320_309# VPB sky130_fd_pr__pfet_01v8_hvt ad=0.135 pd=1.27 as=0.135 ps=1.27 w=1 l=0.15
X15 a_320_309# a_27_47# Z VPB sky130_fd_pr__pfet_01v8_hvt ad=0.28 pd=2.56 as=0.135 ps=1.27 w=1 l=0.15
X16 a_393_47# a_27_47# Z VNB sky130_fd_pr__nfet_01v8 ad=0.08775 pd=0.92 as=0.08775 ps=0.92 w=0.65 l=0.15
X17 a_320_309# a_27_47# Z VPB sky130_fd_pr__pfet_01v8_hvt ad=0.135 pd=1.27 as=0.135 ps=1.27 w=1 l=0.15
X18 VPWR A a_27_47# VPB sky130_fd_pr__pfet_01v8_hvt ad=0.1875 pd=1.375 as=0.26 ps=2.52 w=1 l=0.15
X19 VGND A a_27_47# VNB sky130_fd_pr__nfet_01v8 ad=0.12188 pd=1.025 as=0.169 ps=1.82 w=0.65 l=0.15
.ends

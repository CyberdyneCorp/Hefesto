* NGSPICE file created from sky130_fd_sc_hd__ha_4.ext - technology: sky130A

.subckt sky130_fd_sc_hd__ha_4 A B VGND VNB VPB VPWR COUT SUM
X0 a_467_47# B VGND VNB sky130_fd_pr__nfet_01v8 ad=0.08775 pd=0.92 as=0.09588 ps=0.945 w=0.65 l=0.15
X1 a_1325_47# B a_514_199# VNB sky130_fd_pr__nfet_01v8 ad=0.08775 pd=0.92 as=0.08775 ps=0.92 w=0.65 l=0.15
X2 COUT a_514_199# VGND VNB sky130_fd_pr__nfet_01v8 ad=0.08775 pd=0.92 as=0.11375 ps=1 w=0.65 l=0.15
X3 COUT a_514_199# VGND VNB sky130_fd_pr__nfet_01v8 ad=0.08775 pd=0.92 as=0.08775 ps=0.92 w=0.65 l=0.15
X4 a_467_47# a_514_199# a_79_21# VNB sky130_fd_pr__nfet_01v8 ad=0.08775 pd=0.92 as=0.08775 ps=0.92 w=0.65 l=0.15
X5 a_1167_47# A VGND VNB sky130_fd_pr__nfet_01v8 ad=0.0715 pd=0.87 as=0.08775 ps=0.92 w=0.65 l=0.15
X6 a_717_297# A VPWR VPB sky130_fd_pr__pfet_01v8_hvt ad=0.1475 pd=1.295 as=0.1475 ps=1.295 w=1 l=0.15
X7 VPWR B a_514_199# VPB sky130_fd_pr__pfet_01v8_hvt ad=0.135 pd=1.27 as=0.135 ps=1.27 w=1 l=0.15
X8 VPWR a_514_199# COUT VPB sky130_fd_pr__pfet_01v8_hvt ad=0.26 pd=2.52 as=0.135 ps=1.27 w=1 l=0.15
X9 VPWR a_79_21# SUM VPB sky130_fd_pr__pfet_01v8_hvt ad=0.3825 pd=1.765 as=0.135 ps=1.27 w=1 l=0.15
X10 VGND A a_1325_47# VNB sky130_fd_pr__nfet_01v8 ad=0.11375 pd=1 as=0.08775 ps=0.92 w=0.65 l=0.15
X11 a_514_199# A VPWR VPB sky130_fd_pr__pfet_01v8_hvt ad=0.135 pd=1.27 as=0.23 ps=1.46 w=1 l=0.15
X12 COUT a_514_199# VPWR VPB sky130_fd_pr__pfet_01v8_hvt ad=0.135 pd=1.27 as=0.135 ps=1.27 w=1 l=0.15
X13 a_79_21# a_514_199# a_467_47# VNB sky130_fd_pr__nfet_01v8 ad=0.08775 pd=0.92 as=0.169 ps=1.82 w=0.65 l=0.15
X14 VPWR a_514_199# COUT VPB sky130_fd_pr__pfet_01v8_hvt ad=0.135 pd=1.27 as=0.135 ps=1.27 w=1 l=0.15
X15 SUM a_79_21# VPWR VPB sky130_fd_pr__pfet_01v8_hvt ad=0.135 pd=1.27 as=0.135 ps=1.27 w=1 l=0.15
X16 VPWR a_514_199# a_79_21# VPB sky130_fd_pr__pfet_01v8_hvt ad=0.1475 pd=1.295 as=0.135 ps=1.27 w=1 l=0.15
X17 VGND A a_467_47# VNB sky130_fd_pr__nfet_01v8 ad=0.09588 pd=0.945 as=0.08775 ps=0.92 w=0.65 l=0.15
X18 VPWR a_79_21# SUM VPB sky130_fd_pr__pfet_01v8_hvt ad=0.135 pd=1.27 as=0.135 ps=1.27 w=1 l=0.15
X19 COUT a_514_199# VPWR VPB sky130_fd_pr__pfet_01v8_hvt ad=0.135 pd=1.27 as=0.175 ps=1.35 w=1 l=0.15
X20 VGND a_79_21# SUM VNB sky130_fd_pr__nfet_01v8 ad=0.08775 pd=0.92 as=0.08775 ps=0.92 w=0.65 l=0.15
X21 VGND a_79_21# SUM VNB sky130_fd_pr__nfet_01v8 ad=0.169 pd=1.82 as=0.08775 ps=0.92 w=0.65 l=0.15
X22 SUM a_79_21# VGND VNB sky130_fd_pr__nfet_01v8 ad=0.08775 pd=0.92 as=0.08775 ps=0.92 w=0.65 l=0.15
X23 a_79_21# a_514_199# VPWR VPB sky130_fd_pr__pfet_01v8_hvt ad=0.135 pd=1.27 as=0.3825 ps=1.765 w=1 l=0.15
X24 a_514_199# B a_1167_47# VNB sky130_fd_pr__nfet_01v8 ad=0.08775 pd=0.92 as=0.0715 ps=0.87 w=0.65 l=0.15
X25 VPWR A a_890_297# VPB sky130_fd_pr__pfet_01v8_hvt ad=0.23 pd=1.46 as=0.2875 ps=1.575 w=1 l=0.15
X26 VPWR A a_514_199# VPB sky130_fd_pr__pfet_01v8_hvt ad=0.175 pd=1.35 as=0.135 ps=1.27 w=1 l=0.15
X27 VGND B a_467_47# VNB sky130_fd_pr__nfet_01v8 ad=0.169 pd=1.82 as=0.08775 ps=0.92 w=0.65 l=0.15
X28 VGND a_514_199# COUT VNB sky130_fd_pr__nfet_01v8 ad=0.08775 pd=0.92 as=0.08775 ps=0.92 w=0.65 l=0.15
X29 VGND a_514_199# COUT VNB sky130_fd_pr__nfet_01v8 ad=0.169 pd=1.82 as=0.08775 ps=0.92 w=0.65 l=0.15
X30 a_890_297# B a_79_21# VPB sky130_fd_pr__pfet_01v8_hvt ad=0.2875 pd=1.575 as=0.135 ps=1.27 w=1 l=0.15
X31 a_514_199# B VPWR VPB sky130_fd_pr__pfet_01v8_hvt ad=0.135 pd=1.27 as=0.135 ps=1.27 w=1 l=0.15
X32 VGND A a_467_47# VNB sky130_fd_pr__nfet_01v8 ad=0.08775 pd=0.92 as=0.18525 ps=1.87 w=0.65 l=0.15
X33 SUM a_79_21# VPWR VPB sky130_fd_pr__pfet_01v8_hvt ad=0.135 pd=1.27 as=0.26 ps=2.52 w=1 l=0.15
X34 a_79_21# B a_717_297# VPB sky130_fd_pr__pfet_01v8_hvt ad=0.135 pd=1.27 as=0.1475 ps=1.295 w=1 l=0.15
X35 SUM a_79_21# VGND VNB sky130_fd_pr__nfet_01v8 ad=0.08775 pd=0.92 as=0.169 ps=1.82 w=0.65 l=0.15
.ends

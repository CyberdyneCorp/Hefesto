* NGSPICE file created from sky130_fd_sc_hd__clkdlybuf4s18_1.ext - technology: sky130A

.subckt sky130_fd_sc_hd__clkdlybuf4s18_1 A VGND VNB VPB VPWR X
X0 VPWR A a_27_47# VPB sky130_fd_pr__pfet_01v8_hvt ad=0.3184 pd=1.68 as=0.265 ps=2.53 w=1 l=0.15
X1 X a_394_47# VGND VNB sky130_fd_pr__nfet_01v8 ad=0.1113 pd=1.37 as=0.20835 ps=1.33 w=0.42 l=0.15
X2 VGND a_282_47# a_394_47# VNB sky130_fd_pr__nfet_01v8 ad=0.20835 pd=1.33 as=0.17225 ps=1.83 w=0.65 l=0.18
X3 X a_394_47# VPWR VPB sky130_fd_pr__pfet_01v8_hvt ad=0.265 pd=2.53 as=0.3229 ps=1.68 w=1 l=0.15
X4 a_282_47# a_27_47# VPWR VPB sky130_fd_pr__pfet_01v8_hvt ad=0.2173 pd=2.17 as=0.3184 ps=1.68 w=0.82 l=0.18
X5 VGND A a_27_47# VNB sky130_fd_pr__nfet_01v8 ad=0.20835 pd=1.33 as=0.1113 ps=1.37 w=0.42 l=0.15
X6 a_282_47# a_27_47# VGND VNB sky130_fd_pr__nfet_01v8 ad=0.17225 pd=1.83 as=0.20835 ps=1.33 w=0.65 l=0.18
X7 VPWR a_282_47# a_394_47# VPB sky130_fd_pr__pfet_01v8_hvt ad=0.3229 pd=1.68 as=0.2173 ps=2.17 w=0.82 l=0.18
.ends

* NGSPICE file created from sky130_fd_sc_hd__sdfsbp_2.ext - technology: sky130A

.subckt sky130_fd_sc_hd__sdfsbp_2 CLK D SCD SCE SET_B VGND VNB VPB VPWR Q Q_N
X0 a_1006_47# a_818_47# a_181_47# VPB sky130_fd_pr__pfet_01v8_hvt ad=0.06825 pd=0.745 as=0.1092 ps=1.36 w=0.42 l=0.15
X1 a_1781_295# a_1597_329# VPWR VPB sky130_fd_pr__pfet_01v8_hvt ad=0.1092 pd=1.36 as=0.1092 ps=1.36 w=0.42 l=0.15
X2 VGND a_328_21# a_265_47# VNB sky130_fd_pr__nfet_01v8 ad=0.1092 pd=1.36 as=0.06615 ps=0.735 w=0.42 l=0.15
X3 Q_N a_1597_329# VGND VNB sky130_fd_pr__nfet_01v8 ad=0.08775 pd=0.92 as=0.169 ps=1.82 w=0.65 l=0.15
X4 a_818_47# a_652_47# VGND VNB sky130_fd_pr__nfet_01v8 ad=0.1092 pd=1.36 as=0.0567 ps=0.69 w=0.42 l=0.15
X5 VPWR a_2501_47# Q VPB sky130_fd_pr__pfet_01v8_hvt ad=0.31 pd=2.62 as=0.135 ps=1.27 w=1 l=0.15
X6 a_1090_47# a_818_47# a_1006_47# VNB sky130_fd_pr__nfet_01v8 ad=0.0441 pd=0.63 as=0.0567 ps=0.69 w=0.42 l=0.15
X7 VPWR SCD a_27_369# VPB sky130_fd_pr__pfet_01v8_hvt ad=0.0864 pd=0.91 as=0.1664 ps=1.8 w=0.64 l=0.15
X8 Q a_2501_47# VPWR VPB sky130_fd_pr__pfet_01v8_hvt ad=0.135 pd=1.27 as=0.149 ps=1.325 w=1 l=0.15
X9 VPWR SET_B a_1132_21# VPB sky130_fd_pr__pfet_01v8_hvt ad=0.1428 pd=1.27 as=0.0714 ps=0.76 w=0.42 l=0.15
X10 a_1517_47# a_1006_47# VGND VNB sky130_fd_pr__nfet_01v8 ad=0.2336 pd=1.37 as=0.09575 ps=0.965 w=0.64 l=0.15
X11 VGND a_1132_21# a_1090_47# VNB sky130_fd_pr__nfet_01v8 ad=0.1092 pd=1.36 as=0.0441 ps=0.63 w=0.42 l=0.15
X12 VGND a_1597_329# a_2501_47# VNB sky130_fd_pr__nfet_01v8 ad=0.097 pd=0.975 as=0.1092 ps=1.36 w=0.42 l=0.15
X13 a_181_47# SCE a_109_47# VNB sky130_fd_pr__nfet_01v8 ad=0.0567 pd=0.69 as=0.0441 ps=0.63 w=0.42 l=0.15
X14 VPWR a_1781_295# a_1723_413# VPB sky130_fd_pr__pfet_01v8_hvt ad=0.08505 pd=0.825 as=0.0609 ps=0.71 w=0.42 l=0.15
X15 VGND SCE a_328_21# VNB sky130_fd_pr__nfet_01v8 ad=0.1092 pd=1.36 as=0.1092 ps=1.36 w=0.42 l=0.15
X16 a_1006_47# a_652_47# a_181_47# VNB sky130_fd_pr__nfet_01v8 ad=0.0567 pd=0.69 as=0.1092 ps=1.36 w=0.42 l=0.15
X17 VGND a_2501_47# Q VNB sky130_fd_pr__nfet_01v8 ad=0.2015 pd=1.92 as=0.08775 ps=0.92 w=0.65 l=0.15
X18 a_818_47# a_652_47# VPWR VPB sky130_fd_pr__pfet_01v8_hvt ad=0.1664 pd=1.8 as=0.0864 ps=0.91 w=0.64 l=0.15
X19 VGND SET_B a_1885_47# VNB sky130_fd_pr__nfet_01v8 ad=0.07035 pd=0.755 as=0.0735 ps=0.77 w=0.42 l=0.15
X20 VPWR SCE a_328_21# VPB sky130_fd_pr__pfet_01v8_hvt ad=0.1664 pd=1.8 as=0.16283 ps=1.8 w=0.64 l=0.15
X21 a_1597_329# a_818_47# a_1517_47# VNB sky130_fd_pr__nfet_01v8 ad=0.122 pd=1.09 as=0.2336 ps=1.37 w=0.64 l=0.15
X22 a_181_47# D a_193_369# VPB sky130_fd_pr__pfet_01v8_hvt ad=0.1056 pd=0.97 as=0.0672 ps=0.85 w=0.64 l=0.15
X23 a_27_369# a_328_21# a_181_47# VPB sky130_fd_pr__pfet_01v8_hvt ad=0.16283 pd=1.8 as=0.1056 ps=0.97 w=0.64 l=0.15
X24 a_1597_329# a_652_47# a_1525_329# VPB sky130_fd_pr__pfet_01v8_hvt ad=0.1533 pd=1.32 as=0.0882 ps=1.05 w=0.84 l=0.15
X25 a_265_47# D a_181_47# VNB sky130_fd_pr__nfet_01v8 ad=0.06615 pd=0.735 as=0.0567 ps=0.69 w=0.42 l=0.15
X26 a_1781_295# a_1597_329# VGND VNB sky130_fd_pr__nfet_01v8 ad=0.1113 pd=1.37 as=0.07035 ps=0.755 w=0.42 l=0.15
X27 a_1813_47# a_652_47# a_1597_329# VNB sky130_fd_pr__nfet_01v8 ad=0.0441 pd=0.63 as=0.122 ps=1.09 w=0.42 l=0.15
X28 a_1350_47# a_1006_47# a_1132_21# VNB sky130_fd_pr__nfet_01v8 ad=0.0441 pd=0.63 as=0.1092 ps=1.36 w=0.42 l=0.15
X29 Q a_2501_47# VGND VNB sky130_fd_pr__nfet_01v8 ad=0.08775 pd=0.92 as=0.097 ps=0.975 w=0.65 l=0.15
X30 a_193_369# SCE VPWR VPB sky130_fd_pr__pfet_01v8_hvt ad=0.0672 pd=0.85 as=0.0864 ps=0.91 w=0.64 l=0.15
X31 a_1525_329# a_1006_47# VPWR VPB sky130_fd_pr__pfet_01v8_hvt ad=0.0882 pd=1.05 as=0.1428 ps=1.27 w=0.84 l=0.15
X32 a_1723_413# a_818_47# a_1597_329# VPB sky130_fd_pr__pfet_01v8_hvt ad=0.0609 pd=0.71 as=0.1533 ps=1.32 w=0.42 l=0.15
X33 a_1885_47# a_1781_295# a_1813_47# VNB sky130_fd_pr__nfet_01v8 ad=0.0735 pd=0.77 as=0.0441 ps=0.63 w=0.42 l=0.15
X34 VPWR a_1597_329# Q_N VPB sky130_fd_pr__pfet_01v8_hvt ad=0.325 pd=2.65 as=0.135 ps=1.27 w=1 l=0.15
X35 VGND CLK a_652_47# VNB sky130_fd_pr__nfet_01v8 ad=0.0567 pd=0.69 as=0.1092 ps=1.36 w=0.42 l=0.15
X36 VPWR CLK a_652_47# VPB sky130_fd_pr__pfet_01v8_hvt ad=0.0864 pd=0.91 as=0.1664 ps=1.8 w=0.64 l=0.15
X37 VPWR a_1132_21# a_1102_413# VPB sky130_fd_pr__pfet_01v8_hvt ad=0.09345 pd=0.865 as=0.063 ps=0.72 w=0.42 l=0.15
X38 a_1132_21# a_1006_47# VPWR VPB sky130_fd_pr__pfet_01v8_hvt ad=0.0714 pd=0.76 as=0.09345 ps=0.865 w=0.42 l=0.15
X39 VGND SET_B a_1350_47# VNB sky130_fd_pr__nfet_01v8 ad=0.09575 pd=0.965 as=0.0441 ps=0.63 w=0.42 l=0.15
X40 VGND a_1597_329# Q_N VNB sky130_fd_pr__nfet_01v8 ad=0.21125 pd=1.95 as=0.08775 ps=0.92 w=0.65 l=0.15
X41 a_1102_413# a_652_47# a_1006_47# VPB sky130_fd_pr__pfet_01v8_hvt ad=0.063 pd=0.72 as=0.06825 ps=0.745 w=0.42 l=0.15
X42 Q_N a_1597_329# VPWR VPB sky130_fd_pr__pfet_01v8_hvt ad=0.135 pd=1.27 as=0.26 ps=2.52 w=1 l=0.15
X43 VPWR a_1597_329# a_2501_47# VPB sky130_fd_pr__pfet_01v8_hvt ad=0.149 pd=1.325 as=0.1664 ps=1.8 w=0.64 l=0.15
X44 a_1597_329# SET_B VPWR VPB sky130_fd_pr__pfet_01v8_hvt ad=0.1092 pd=1.36 as=0.08505 ps=0.825 w=0.42 l=0.15
X45 a_109_47# SCD VGND VNB sky130_fd_pr__nfet_01v8 ad=0.0441 pd=0.63 as=0.1092 ps=1.36 w=0.42 l=0.15
C0 VPB VNB 2.81966f
.ends

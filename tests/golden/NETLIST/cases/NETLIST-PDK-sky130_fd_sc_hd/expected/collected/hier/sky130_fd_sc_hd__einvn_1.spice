* NGSPICE file created from sky130_fd_sc_hd__einvn_1.ext - technology: sky130A

.subckt sky130_fd_sc_hd__einvn_1 A TE_B VGND VNB VPB VPWR Z
X0 VPWR TE_B a_27_47# VPB sky130_fd_pr__pfet_01v8_hvt ad=0.149 pd=1.325 as=0.1664 ps=1.8 w=0.64 l=0.15
X1 a_204_297# TE_B VPWR VPB sky130_fd_pr__pfet_01v8_hvt ad=0.3675 pd=1.735 as=0.149 ps=1.325 w=1 l=0.15
X2 Z A a_204_297# VPB sky130_fd_pr__pfet_01v8_hvt ad=0.26 pd=2.52 as=0.3675 ps=1.735 w=1 l=0.15
X3 Z A a_286_47# VNB sky130_fd_pr__nfet_01v8 ad=0.169 pd=1.82 as=0.10563 ps=0.975 w=0.65 l=0.15
X4 a_286_47# a_27_47# VGND VNB sky130_fd_pr__nfet_01v8 ad=0.10563 pd=0.975 as=0.23025 ps=1.385 w=0.65 l=0.15
X5 VGND TE_B a_27_47# VNB sky130_fd_pr__nfet_01v8 ad=0.23025 pd=1.385 as=0.1092 ps=1.36 w=0.42 l=0.15
.ends

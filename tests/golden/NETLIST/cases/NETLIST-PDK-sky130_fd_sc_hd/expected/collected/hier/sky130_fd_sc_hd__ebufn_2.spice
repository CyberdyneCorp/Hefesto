* NGSPICE file created from sky130_fd_sc_hd__ebufn_2.ext - technology: sky130A

.subckt sky130_fd_sc_hd__ebufn_2 A TE_B VGND VNB VPB VPWR Z
X0 a_320_309# a_27_47# Z VPB sky130_fd_pr__pfet_01v8_hvt ad=0.26 pd=2.52 as=0.135 ps=1.27 w=1 l=0.15
X1 Z a_27_47# a_320_309# VPB sky130_fd_pr__pfet_01v8_hvt ad=0.135 pd=1.27 as=0.37025 ps=1.745 w=1 l=0.15
X2 VPWR A a_27_47# VPB sky130_fd_pr__pfet_01v8_hvt ad=0.12 pd=1.015 as=0.1664 ps=1.8 w=0.64 l=0.15
X3 VGND a_214_47# a_392_47# VNB sky130_fd_pr__nfet_01v8 ad=0.08775 pd=0.92 as=0.169 ps=1.82 w=0.65 l=0.15
X4 a_214_47# TE_B VPWR VPB sky130_fd_pr__pfet_01v8_hvt ad=0.1664 pd=1.8 as=0.12 ps=1.015 w=0.64 l=0.15
X5 a_320_309# TE_B VPWR VPB sky130_fd_pr__pfet_01v8_hvt ad=0.37025 pd=1.745 as=0.1269 ps=1.21 w=0.94 l=0.15
X6 a_392_47# a_214_47# VGND VNB sky130_fd_pr__nfet_01v8 ad=0.12513 pd=1.035 as=0.08775 ps=0.92 w=0.65 l=0.15
X7 VPWR TE_B a_320_309# VPB sky130_fd_pr__pfet_01v8_hvt ad=0.1269 pd=1.21 as=0.2444 ps=2.4 w=0.94 l=0.15
X8 Z a_27_47# a_392_47# VNB sky130_fd_pr__nfet_01v8 ad=0.08775 pd=0.92 as=0.12513 ps=1.035 w=0.65 l=0.15
X9 a_214_47# TE_B VGND VNB sky130_fd_pr__nfet_01v8 ad=0.1092 pd=1.36 as=0.07875 ps=0.795 w=0.42 l=0.15
X10 a_392_47# a_27_47# Z VNB sky130_fd_pr__nfet_01v8 ad=0.169 pd=1.82 as=0.08775 ps=0.92 w=0.65 l=0.15
X11 VGND A a_27_47# VNB sky130_fd_pr__nfet_01v8 ad=0.07875 pd=0.795 as=0.1092 ps=1.36 w=0.42 l=0.15
.ends

* NGSPICE file created from sky130_fd_sc_hd__sdfrbp_2.ext - technology: sky130A

.subckt sky130_fd_sc_hd__sdfrbp_2 CLK D RESET_B SCD SCE VGND VNB VPB VPWR Q Q_N
X0 a_193_47# a_27_47# VPWR VPB sky130_fd_pr__pfet_01v8_hvt ad=0.265 pd=2.53 as=0.1425 ps=1.285 w=1 l=0.15
X1 a_780_389# a_299_66# a_620_389# VPB sky130_fd_pr__pfet_01v8_hvt ad=0.0756 pd=0.82 as=0.1755 ps=1.19 w=0.54 l=0.15
X2 a_1245_303# a_1079_413# VPWR VPB sky130_fd_pr__pfet_01v8_hvt ad=0.12075 pd=1.165 as=0.2184 ps=2.2 w=0.84 l=0.15
X3 VPWR a_1592_47# a_1767_21# VPB sky130_fd_pr__pfet_01v8_hvt ad=0.1092 pd=1.36 as=0.0567 ps=0.69 w=0.42 l=0.15
X4 VGND a_1767_21# Q VNB sky130_fd_pr__nfet_01v8 ad=0.0975 pd=0.95 as=0.10075 ps=0.96 w=0.65 l=0.15
X5 VGND a_1767_21# a_1701_47# VNB sky130_fd_pr__nfet_01v8 ad=0.12495 pd=1.015 as=0.06705 ps=0.75 w=0.42 l=0.15
X6 a_1758_413# a_193_47# a_1592_47# VPB sky130_fd_pr__pfet_01v8_hvt ad=0.0546 pd=0.68 as=0.0588 ps=0.7 w=0.42 l=0.15
X7 a_1767_21# a_1592_47# a_1946_47# VNB sky130_fd_pr__nfet_01v8 ad=0.1176 pd=1.4 as=0.05145 ps=0.665 w=0.42 l=0.15
X8 VPWR a_1767_21# a_2135_47# VPB sky130_fd_pr__pfet_01v8_hvt ad=0.149 pd=1.325 as=0.1664 ps=1.8 w=0.64 l=0.15
X9 VGND SCD a_817_66# VNB sky130_fd_pr__nfet_01v8 ad=0.1176 pd=1.4 as=0.0441 ps=0.63 w=0.42 l=0.18
X10 a_538_389# SCE VPWR VPB sky130_fd_pr__pfet_01v8_hvt ad=0.0702 pd=0.8 as=0.0729 ps=0.81 w=0.54 l=0.15
X11 VPWR SCD a_780_389# VPB sky130_fd_pr__pfet_01v8_hvt ad=0.1512 pd=1.64 as=0.0756 ps=0.82 w=0.54 l=0.15
X12 VPWR SCE a_299_66# VPB sky130_fd_pr__pfet_01v8_hvt ad=0.0729 pd=0.81 as=0.189 ps=1.78 w=0.54 l=0.15
X13 a_1767_21# RESET_B VPWR VPB sky130_fd_pr__pfet_01v8_hvt ad=0.0567 pd=0.69 as=0.0798 ps=0.8 w=0.42 l=0.15
X14 a_193_47# a_27_47# VGND VNB sky130_fd_pr__nfet_01v8 ad=0.169 pd=1.82 as=0.08775 ps=0.92 w=0.65 l=0.15
X15 a_620_389# D a_569_119# VNB sky130_fd_pr__nfet_01v8 ad=0.11028 pd=1.065 as=0.0441 ps=0.63 w=0.42 l=0.15
X16 a_1187_47# a_193_47# a_1079_413# VNB sky130_fd_pr__special_nfet_01v8 ad=0.0759 pd=0.8 as=0.063 ps=0.71 w=0.36 l=0.15
X17 Q a_1767_21# VPWR VPB sky130_fd_pr__pfet_01v8_hvt ad=0.155 pd=1.31 as=0.149 ps=1.325 w=1 l=0.15
X18 a_1293_47# a_1245_303# a_1187_47# VNB sky130_fd_pr__nfet_01v8 ad=0.0441 pd=0.63 as=0.0759 ps=0.8 w=0.42 l=0.15
X19 VPWR a_1245_303# a_1191_413# VPB sky130_fd_pr__pfet_01v8_hvt ad=0.1007 pd=0.94 as=0.0567 ps=0.69 w=0.42 l=0.15
X20 Q a_1767_21# VGND VNB sky130_fd_pr__nfet_01v8 ad=0.10075 pd=0.96 as=0.09862 ps=0.98 w=0.65 l=0.15
X21 a_620_389# D a_538_389# VPB sky130_fd_pr__pfet_01v8_hvt ad=0.1755 pd=1.19 as=0.0702 ps=0.8 w=0.54 l=0.15
X22 a_1191_413# a_27_47# a_1079_413# VPB sky130_fd_pr__pfet_01v8_hvt ad=0.0567 pd=0.69 as=0.0861 ps=0.83 w=0.42 l=0.15
X23 Q_N a_2135_47# VGND VNB sky130_fd_pr__nfet_01v8 ad=0.08775 pd=0.92 as=0.0975 ps=0.95 w=0.65 l=0.15
X24 a_569_119# a_299_66# VGND VNB sky130_fd_pr__nfet_01v8 ad=0.0441 pd=0.63 as=0.1092 ps=1.36 w=0.42 l=0.15
X25 VPWR a_1767_21# a_1758_413# VPB sky130_fd_pr__pfet_01v8_hvt ad=0.0798 pd=0.8 as=0.0546 ps=0.68 w=0.42 l=0.15
X26 VGND RESET_B a_1293_47# VNB sky130_fd_pr__nfet_01v8 ad=0.1346 pd=1.15 as=0.0441 ps=0.63 w=0.42 l=0.15
X27 VPWR a_2135_47# Q_N VPB sky130_fd_pr__pfet_01v8_hvt ad=0.31 pd=2.62 as=0.135 ps=1.27 w=1 l=0.15
X28 VGND a_1767_21# a_2135_47# VNB sky130_fd_pr__nfet_01v8 ad=0.09862 pd=0.98 as=0.1092 ps=1.36 w=0.42 l=0.15
X29 a_1191_413# RESET_B VPWR VPB sky130_fd_pr__pfet_01v8_hvt ad=0.1092 pd=1.36 as=0.1007 ps=0.94 w=0.42 l=0.15
X30 a_1079_413# a_27_47# a_620_389# VNB sky130_fd_pr__special_nfet_01v8 ad=0.063 pd=0.71 as=0.0936 ps=1.24 w=0.36 l=0.15
X31 Q_N a_2135_47# VPWR VPB sky130_fd_pr__pfet_01v8_hvt ad=0.135 pd=1.27 as=0.15 ps=1.3 w=1 l=0.15
X32 a_1946_47# RESET_B VGND VNB sky130_fd_pr__nfet_01v8 ad=0.05145 pd=0.665 as=0.12495 ps=1.015 w=0.42 l=0.15
X33 a_1701_47# a_27_47# a_1592_47# VNB sky130_fd_pr__special_nfet_01v8 ad=0.06705 pd=0.75 as=0.0711 ps=0.755 w=0.36 l=0.15
X34 VPWR a_1767_21# Q VPB sky130_fd_pr__pfet_01v8_hvt ad=0.15 pd=1.3 as=0.155 ps=1.31 w=1 l=0.15
X35 a_1592_47# a_193_47# a_1245_303# VNB sky130_fd_pr__special_nfet_01v8 ad=0.0711 pd=0.755 as=0.0935 ps=0.965 w=0.36 l=0.15
X36 VGND SCE a_299_66# VNB sky130_fd_pr__nfet_01v8 ad=0.1092 pd=1.36 as=0.1092 ps=1.36 w=0.42 l=0.15
X37 a_1592_47# a_27_47# a_1245_303# VPB sky130_fd_pr__pfet_01v8_hvt ad=0.0588 pd=0.7 as=0.12075 ps=1.165 w=0.42 l=0.15
X38 a_1245_303# a_1079_413# VGND VNB sky130_fd_pr__nfet_01v8 ad=0.0935 pd=0.965 as=0.1346 ps=1.15 w=0.64 l=0.15
X39 a_1079_413# a_193_47# a_620_389# VPB sky130_fd_pr__pfet_01v8_hvt ad=0.0861 pd=0.83 as=0.1533 ps=1.57 w=0.42 l=0.15
X40 VGND a_2135_47# Q_N VNB sky130_fd_pr__nfet_01v8 ad=0.2015 pd=1.92 as=0.08775 ps=0.92 w=0.65 l=0.15
X41 VPWR CLK a_27_47# VPB sky130_fd_pr__pfet_01v8_hvt ad=0.1425 pd=1.285 as=0.26 ps=2.52 w=1 l=0.15
X42 a_817_66# SCE a_620_389# VNB sky130_fd_pr__nfet_01v8 ad=0.0441 pd=0.63 as=0.11028 ps=1.065 w=0.42 l=0.5
X43 VGND CLK a_27_47# VNB sky130_fd_pr__nfet_01v8 ad=0.08775 pd=0.92 as=0.169 ps=1.82 w=0.65 l=0.15
C0 VPB VNB 2.60741f
.ends

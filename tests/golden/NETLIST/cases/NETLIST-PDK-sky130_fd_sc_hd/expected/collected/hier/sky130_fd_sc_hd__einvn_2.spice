* NGSPICE file created from sky130_fd_sc_hd__einvn_2.ext - technology: sky130A

.subckt sky130_fd_sc_hd__einvn_2 A TE_B VGND VNB VPB VPWR Z
X0 Z A a_204_309# VPB sky130_fd_pr__pfet_01v8_hvt ad=0.26 pd=2.52 as=0.135 ps=1.27 w=1 l=0.15
X1 VGND a_27_47# a_214_120# VNB sky130_fd_pr__nfet_01v8 ad=0.08775 pd=0.92 as=0.16535 ps=1.82 w=0.65 l=0.15
X2 a_204_309# A Z VPB sky130_fd_pr__pfet_01v8_hvt ad=0.135 pd=1.27 as=0.2593 ps=2.56 w=1 l=0.15
X3 Z A a_214_120# VNB sky130_fd_pr__nfet_01v8 ad=0.08775 pd=0.92 as=0.11213 ps=0.995 w=0.65 l=0.15
X4 VPWR TE_B a_27_47# VPB sky130_fd_pr__pfet_01v8_hvt ad=0.1415 pd=1.265 as=0.1664 ps=1.8 w=0.64 l=0.15
X5 VPWR TE_B a_204_309# VPB sky130_fd_pr__pfet_01v8_hvt ad=0.24137 pd=2.4 as=0.1269 ps=1.21 w=0.94 l=0.15
X6 a_204_309# TE_B VPWR VPB sky130_fd_pr__pfet_01v8_hvt ad=0.1269 pd=1.21 as=0.1415 ps=1.265 w=0.94 l=0.15
X7 a_214_120# a_27_47# VGND VNB sky130_fd_pr__nfet_01v8 ad=0.11213 pd=0.995 as=0.08775 ps=0.92 w=0.65 l=0.15
X8 a_214_120# A Z VNB sky130_fd_pr__nfet_01v8 ad=0.169 pd=1.82 as=0.08775 ps=0.92 w=0.65 l=0.15
X9 VGND TE_B a_27_47# VNB sky130_fd_pr__nfet_01v8 ad=0.1079 pd=1.36 as=0.1092 ps=1.36 w=0.42 l=0.15
.ends

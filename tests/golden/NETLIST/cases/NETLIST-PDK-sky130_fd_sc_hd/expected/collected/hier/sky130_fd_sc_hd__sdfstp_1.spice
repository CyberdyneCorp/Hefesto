* NGSPICE file created from sky130_fd_sc_hd__sdfstp_1.ext - technology: sky130A

.subckt sky130_fd_sc_hd__sdfstp_1 CLK D SCD SCE SET_B VGND VNB VPB VPWR Q
X0 VPWR a_1597_329# a_2227_47# VPB sky130_fd_pr__pfet_01v8_hvt ad=0.1506 pd=1.33 as=0.1664 ps=1.8 w=0.64 l=0.15
X1 Q a_2227_47# VGND VNB sky130_fd_pr__nfet_01v8 ad=0.169 pd=1.82 as=0.09805 ps=0.98 w=0.65 l=0.15
X2 a_1597_329# SET_B VPWR VPB sky130_fd_pr__pfet_01v8_hvt ad=0.1092 pd=1.36 as=0.0966 ps=0.88 w=0.42 l=0.15
X3 VPWR SCD a_27_369# VPB sky130_fd_pr__pfet_01v8_hvt ad=0.0864 pd=0.91 as=0.1664 ps=1.8 w=0.64 l=0.15
X4 a_1081_413# a_643_369# a_997_413# VPB sky130_fd_pr__pfet_01v8_hvt ad=0.0756 pd=0.78 as=0.0567 ps=0.69 w=0.42 l=0.15
X5 a_809_369# a_643_369# VGND VNB sky130_fd_pr__nfet_01v8 ad=0.1092 pd=1.36 as=0.0567 ps=0.69 w=0.42 l=0.15
X6 VGND a_1597_329# a_2227_47# VNB sky130_fd_pr__nfet_01v8 ad=0.09805 pd=0.98 as=0.1092 ps=1.36 w=0.42 l=0.15
X7 a_997_413# a_809_369# a_181_47# VPB sky130_fd_pr__pfet_01v8_hvt ad=0.0567 pd=0.69 as=0.1092 ps=1.36 w=0.42 l=0.15
X8 VPWR SET_B a_1129_21# VPB sky130_fd_pr__pfet_01v8_hvt ad=0.1428 pd=1.27 as=0.0714 ps=0.76 w=0.42 l=0.15
X9 a_1347_47# a_997_413# a_1129_21# VNB sky130_fd_pr__nfet_01v8 ad=0.0441 pd=0.63 as=0.1092 ps=1.36 w=0.42 l=0.15
X10 VPWR a_1129_21# a_1081_413# VPB sky130_fd_pr__pfet_01v8_hvt ad=0.1029 pd=0.91 as=0.0756 ps=0.78 w=0.42 l=0.15
X11 a_181_47# SCE a_109_47# VNB sky130_fd_pr__nfet_01v8 ad=0.0567 pd=0.69 as=0.0441 ps=0.63 w=0.42 l=0.15
X12 a_1514_47# a_997_413# VGND VNB sky130_fd_pr__nfet_01v8 ad=0.2384 pd=1.385 as=0.09575 ps=0.965 w=0.64 l=0.15
X13 VPWR a_1781_295# a_1723_413# VPB sky130_fd_pr__pfet_01v8_hvt ad=0.0966 pd=0.88 as=0.0609 ps=0.71 w=0.42 l=0.15
X14 VGND SET_B a_1347_47# VNB sky130_fd_pr__nfet_01v8 ad=0.09575 pd=0.965 as=0.0441 ps=0.63 w=0.42 l=0.15
X15 a_27_369# a_319_21# a_181_47# VPB sky130_fd_pr__pfet_01v8_hvt ad=0.1664 pd=1.8 as=0.0864 ps=0.91 w=0.64 l=0.15
X16 VGND SCE a_319_21# VNB sky130_fd_pr__nfet_01v8 ad=0.1092 pd=1.36 as=0.1092 ps=1.36 w=0.42 l=0.15
X17 a_1597_329# a_809_369# a_1514_47# VNB sky130_fd_pr__nfet_01v8 ad=0.1241 pd=1.1 as=0.2384 ps=1.385 w=0.64 l=0.15
X18 a_1815_47# a_643_369# a_1597_329# VNB sky130_fd_pr__nfet_01v8 ad=0.0441 pd=0.63 as=0.1241 ps=1.1 w=0.42 l=0.15
X19 a_181_47# D a_193_369# VPB sky130_fd_pr__pfet_01v8_hvt ad=0.0864 pd=0.91 as=0.0672 ps=0.85 w=0.64 l=0.15
X20 VGND SET_B a_1887_47# VNB sky130_fd_pr__nfet_01v8 ad=0.0882 pd=0.84 as=0.0693 ps=0.75 w=0.42 l=0.15
X21 a_1597_329# a_643_369# a_1525_329# VPB sky130_fd_pr__pfet_01v8_hvt ad=0.1533 pd=1.32 as=0.0882 ps=1.05 w=0.84 l=0.15
X22 a_265_47# D a_181_47# VNB sky130_fd_pr__nfet_01v8 ad=0.0567 pd=0.69 as=0.0567 ps=0.69 w=0.42 l=0.15
X23 a_997_413# a_643_369# a_181_47# VNB sky130_fd_pr__nfet_01v8 ad=0.0567 pd=0.69 as=0.1092 ps=1.36 w=0.42 l=0.15
X24 a_1781_295# a_1597_329# VGND VNB sky130_fd_pr__nfet_01v8 ad=0.1596 pd=1.6 as=0.0882 ps=0.84 w=0.42 l=0.15
X25 a_1887_47# a_1781_295# a_1815_47# VNB sky130_fd_pr__nfet_01v8 ad=0.0693 pd=0.75 as=0.0441 ps=0.63 w=0.42 l=0.15
X26 a_1087_47# a_809_369# a_997_413# VNB sky130_fd_pr__nfet_01v8 ad=0.0441 pd=0.63 as=0.0567 ps=0.69 w=0.42 l=0.15
X27 a_193_369# SCE VPWR VPB sky130_fd_pr__pfet_01v8_hvt ad=0.0672 pd=0.85 as=0.0864 ps=0.91 w=0.64 l=0.15
X28 a_809_369# a_643_369# VPWR VPB sky130_fd_pr__pfet_01v8_hvt ad=0.1664 pd=1.8 as=0.0864 ps=0.91 w=0.64 l=0.15
X29 a_1525_329# a_997_413# VPWR VPB sky130_fd_pr__pfet_01v8_hvt ad=0.0882 pd=1.05 as=0.1428 ps=1.27 w=0.84 l=0.15
X30 a_1723_413# a_809_369# a_1597_329# VPB sky130_fd_pr__pfet_01v8_hvt ad=0.0609 pd=0.71 as=0.1533 ps=1.32 w=0.42 l=0.15
X31 VPWR SCE a_319_21# VPB sky130_fd_pr__pfet_01v8_hvt ad=0.1664 pd=1.8 as=0.1664 ps=1.8 w=0.64 l=0.15
X32 Q a_2227_47# VPWR VPB sky130_fd_pr__pfet_01v8_hvt ad=0.26 pd=2.52 as=0.1506 ps=1.33 w=1 l=0.15
X33 VPWR CLK a_643_369# VPB sky130_fd_pr__pfet_01v8_hvt ad=0.0864 pd=0.91 as=0.1664 ps=1.8 w=0.64 l=0.15
X34 a_1129_21# a_997_413# VPWR VPB sky130_fd_pr__pfet_01v8_hvt ad=0.0714 pd=0.76 as=0.1029 ps=0.91 w=0.42 l=0.15
X35 VGND a_319_21# a_265_47# VNB sky130_fd_pr__nfet_01v8 ad=0.1218 pd=1.42 as=0.0567 ps=0.69 w=0.42 l=0.15
X36 VGND a_1129_21# a_1087_47# VNB sky130_fd_pr__nfet_01v8 ad=0.1092 pd=1.36 as=0.0441 ps=0.63 w=0.42 l=0.15
X37 VGND CLK a_643_369# VNB sky130_fd_pr__nfet_01v8 ad=0.0567 pd=0.69 as=0.1092 ps=1.36 w=0.42 l=0.15
X38 a_1781_295# a_1597_329# VPWR VPB sky130_fd_pr__pfet_01v8_hvt ad=0.1092 pd=1.36 as=0.1092 ps=1.36 w=0.42 l=0.15
X39 a_109_47# SCD VGND VNB sky130_fd_pr__nfet_01v8 ad=0.0441 pd=0.63 as=0.1092 ps=1.36 w=0.42 l=0.15
C0 VPB VNB 2.46528f
.ends

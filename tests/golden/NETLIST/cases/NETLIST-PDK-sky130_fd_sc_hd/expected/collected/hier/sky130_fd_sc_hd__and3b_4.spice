* NGSPICE file created from sky130_fd_sc_hd__and3b_4.ext - technology: sky130A

.subckt sky130_fd_sc_hd__and3b_4 A_N B C VGND VNB VPB VPWR X
X0 a_98_199# A_N VGND VNB sky130_fd_pr__nfet_01v8 ad=0.1491 pd=1.55 as=0.10837 ps=1.01 w=0.42 l=0.15
X1 X a_56_297# VGND VNB sky130_fd_pr__nfet_01v8 ad=0.091 pd=0.93 as=0.091 ps=0.93 w=0.65 l=0.15
X2 VPWR a_56_297# X VPB sky130_fd_pr__pfet_01v8_hvt ad=0.15825 pd=1.36 as=0.14 ps=1.28 w=1 l=0.15
X3 VGND a_56_297# X VNB sky130_fd_pr__nfet_01v8 ad=0.10837 pd=1.01 as=0.091 ps=0.93 w=0.65 l=0.15
X4 VPWR a_98_199# a_56_297# VPB sky130_fd_pr__pfet_01v8_hvt ad=0.1875 pd=1.375 as=0.33 ps=2.66 w=1 l=0.15
X5 VPWR a_56_297# X VPB sky130_fd_pr__pfet_01v8_hvt ad=0.135 pd=1.27 as=0.145 ps=1.29 w=1 l=0.15
X6 VGND a_56_297# X VNB sky130_fd_pr__nfet_01v8 ad=0.091 pd=0.93 as=0.091 ps=0.93 w=0.65 l=0.15
X7 a_257_47# B a_152_47# VNB sky130_fd_pr__nfet_01v8 ad=0.07475 pd=0.88 as=0.12188 ps=1.025 w=0.65 l=0.15
X8 X a_56_297# VGND VNB sky130_fd_pr__nfet_01v8 ad=0.091 pd=0.93 as=0.13813 ps=1.075 w=0.65 l=0.15
X9 X a_56_297# VPWR VPB sky130_fd_pr__pfet_01v8_hvt ad=0.145 pd=1.29 as=0.1775 ps=1.355 w=1 l=0.15
X10 a_152_47# a_98_199# a_56_297# VNB sky130_fd_pr__nfet_01v8 ad=0.12188 pd=1.025 as=0.19825 ps=1.91 w=0.65 l=0.15
X11 VPWR C a_56_297# VPB sky130_fd_pr__pfet_01v8_hvt ad=0.1775 pd=1.355 as=0.15 ps=1.3 w=1 l=0.15
X12 a_98_199# A_N VPWR VPB sky130_fd_pr__pfet_01v8_hvt ad=0.1197 pd=1.41 as=0.15825 ps=1.36 w=0.42 l=0.15
X13 a_56_297# B VPWR VPB sky130_fd_pr__pfet_01v8_hvt ad=0.15 pd=1.3 as=0.1875 ps=1.375 w=1 l=0.15
X14 VGND C a_257_47# VNB sky130_fd_pr__nfet_01v8 ad=0.13813 pd=1.075 as=0.07475 ps=0.88 w=0.65 l=0.15
X15 X a_56_297# VPWR VPB sky130_fd_pr__pfet_01v8_hvt ad=0.14 pd=1.28 as=0.135 ps=1.27 w=1 l=0.15
.ends

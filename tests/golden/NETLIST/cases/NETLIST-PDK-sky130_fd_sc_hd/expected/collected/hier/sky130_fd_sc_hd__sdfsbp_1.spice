* NGSPICE file created from sky130_fd_sc_hd__sdfsbp_1.ext - technology: sky130A

.subckt sky130_fd_sc_hd__sdfsbp_1 CLK D SCD SCE SET_B VGND VNB VPB VPWR Q Q_N
X0 Q a_2412_47# VGND VNB sky130_fd_pr__nfet_01v8 ad=0.169 pd=1.82 as=0.097 ps=0.975 w=0.65 l=0.15
X1 a_1129_21# a_997_413# VPWR VPB sky130_fd_pr__pfet_01v8_hvt ad=0.07035 pd=0.755 as=0.0924 ps=0.86 w=0.42 l=0.15
X2 VPWR SCD a_27_369# VPB sky130_fd_pr__pfet_01v8_hvt ad=0.0864 pd=0.91 as=0.1664 ps=1.8 w=0.64 l=0.15
X3 a_1081_413# a_643_369# a_997_413# VPB sky130_fd_pr__pfet_01v8_hvt ad=0.0756 pd=0.78 as=0.0567 ps=0.69 w=0.42 l=0.15
X4 a_1587_329# SET_B VPWR VPB sky130_fd_pr__pfet_01v8_hvt ad=0.1092 pd=1.36 as=0.10395 ps=0.915 w=0.42 l=0.15
X5 a_809_369# a_643_369# VGND VNB sky130_fd_pr__nfet_01v8 ad=0.1092 pd=1.36 as=0.0567 ps=0.69 w=0.42 l=0.15
X6 a_997_413# a_809_369# a_181_47# VPB sky130_fd_pr__pfet_01v8_hvt ad=0.0567 pd=0.69 as=0.1092 ps=1.36 w=0.42 l=0.15
X7 a_1347_47# a_997_413# a_1129_21# VNB sky130_fd_pr__nfet_01v8 ad=0.0441 pd=0.63 as=0.1092 ps=1.36 w=0.42 l=0.15
X8 VPWR a_1129_21# a_1081_413# VPB sky130_fd_pr__pfet_01v8_hvt ad=0.0924 pd=0.86 as=0.0756 ps=0.78 w=0.42 l=0.15
X9 a_1770_295# a_1587_329# VPWR VPB sky130_fd_pr__pfet_01v8_hvt ad=0.1092 pd=1.36 as=0.1092 ps=1.36 w=0.42 l=0.15
X10 Q_N a_1587_329# VPWR VPB sky130_fd_pr__pfet_01v8_hvt ad=0.26 pd=2.52 as=0.26 ps=2.52 w=1 l=0.15
X11 a_1807_47# a_643_369# a_1587_329# VNB sky130_fd_pr__nfet_01v8 ad=0.0441 pd=0.63 as=0.1262 ps=1.11 w=0.42 l=0.15
X12 VPWR SET_B a_1129_21# VPB sky130_fd_pr__pfet_01v8_hvt ad=0.1428 pd=1.27 as=0.07035 ps=0.755 w=0.42 l=0.15
X13 Q_N a_1587_329# VGND VNB sky130_fd_pr__nfet_01v8 ad=0.169 pd=1.82 as=0.169 ps=1.82 w=0.65 l=0.15
X14 a_181_47# SCE a_109_47# VNB sky130_fd_pr__nfet_01v8 ad=0.0567 pd=0.69 as=0.0441 ps=0.63 w=0.42 l=0.15
X15 a_1514_47# a_997_413# VGND VNB sky130_fd_pr__nfet_01v8 ad=0.2224 pd=1.335 as=0.09575 ps=0.965 w=0.64 l=0.15
X16 a_1587_329# a_809_369# a_1514_47# VNB sky130_fd_pr__nfet_01v8 ad=0.1262 pd=1.11 as=0.2224 ps=1.335 w=0.64 l=0.15
X17 VPWR a_1770_295# a_1712_413# VPB sky130_fd_pr__pfet_01v8_hvt ad=0.10395 pd=0.915 as=0.0609 ps=0.71 w=0.42 l=0.15
X18 VGND SET_B a_1347_47# VNB sky130_fd_pr__nfet_01v8 ad=0.09575 pd=0.965 as=0.0441 ps=0.63 w=0.42 l=0.15
X19 Q a_2412_47# VPWR VPB sky130_fd_pr__pfet_01v8_hvt ad=0.26 pd=2.52 as=0.149 ps=1.325 w=1 l=0.15
X20 a_1879_47# a_1770_295# a_1807_47# VNB sky130_fd_pr__nfet_01v8 ad=0.1029 pd=0.91 as=0.0441 ps=0.63 w=0.42 l=0.15
X21 a_27_369# a_319_21# a_181_47# VPB sky130_fd_pr__pfet_01v8_hvt ad=0.1664 pd=1.8 as=0.0864 ps=0.91 w=0.64 l=0.15
X22 VGND SCE a_319_21# VNB sky130_fd_pr__nfet_01v8 ad=0.1092 pd=1.36 as=0.1092 ps=1.36 w=0.42 l=0.15
X23 a_181_47# D a_193_369# VPB sky130_fd_pr__pfet_01v8_hvt ad=0.0864 pd=0.91 as=0.0672 ps=0.85 w=0.64 l=0.15
X24 a_265_47# D a_181_47# VNB sky130_fd_pr__nfet_01v8 ad=0.0567 pd=0.69 as=0.0567 ps=0.69 w=0.42 l=0.15
X25 a_997_413# a_643_369# a_181_47# VNB sky130_fd_pr__nfet_01v8 ad=0.0567 pd=0.69 as=0.1092 ps=1.36 w=0.42 l=0.15
X26 VGND a_1587_329# a_2412_47# VNB sky130_fd_pr__nfet_01v8 ad=0.097 pd=0.975 as=0.1092 ps=1.36 w=0.42 l=0.15
X27 a_1087_47# a_809_369# a_997_413# VNB sky130_fd_pr__nfet_01v8 ad=0.0441 pd=0.63 as=0.0567 ps=0.69 w=0.42 l=0.15
X28 a_193_369# SCE VPWR VPB sky130_fd_pr__pfet_01v8_hvt ad=0.0672 pd=0.85 as=0.0864 ps=0.91 w=0.64 l=0.15
X29 a_809_369# a_643_369# VPWR VPB sky130_fd_pr__pfet_01v8_hvt ad=0.1664 pd=1.8 as=0.0864 ps=0.91 w=0.64 l=0.15
X30 VPWR SCE a_319_21# VPB sky130_fd_pr__pfet_01v8_hvt ad=0.1664 pd=1.8 as=0.1664 ps=1.8 w=0.64 l=0.15
X31 VGND SET_B a_1879_47# VNB sky130_fd_pr__nfet_01v8 ad=0.08505 pd=0.825 as=0.1029 ps=0.91 w=0.42 l=0.15
X32 VPWR a_1587_329# a_2412_47# VPB sky130_fd_pr__pfet_01v8_hvt ad=0.149 pd=1.325 as=0.1664 ps=1.8 w=0.64 l=0.15
X33 VPWR CLK a_643_369# VPB sky130_fd_pr__pfet_01v8_hvt ad=0.0864 pd=0.91 as=0.1664 ps=1.8 w=0.64 l=0.15
X34 a_1514_329# a_997_413# VPWR VPB sky130_fd_pr__pfet_01v8_hvt ad=0.0903 pd=1.055 as=0.1428 ps=1.27 w=0.84 l=0.15
X35 a_1587_329# a_643_369# a_1514_329# VPB sky130_fd_pr__pfet_01v8_hvt ad=0.15225 pd=1.315 as=0.0903 ps=1.055 w=0.84 l=0.15
X36 a_1712_413# a_809_369# a_1587_329# VPB sky130_fd_pr__pfet_01v8_hvt ad=0.0609 pd=0.71 as=0.15225 ps=1.315 w=0.42 l=0.15
X37 VGND a_319_21# a_265_47# VNB sky130_fd_pr__nfet_01v8 ad=0.1218 pd=1.42 as=0.0567 ps=0.69 w=0.42 l=0.15
X38 VGND a_1129_21# a_1087_47# VNB sky130_fd_pr__nfet_01v8 ad=0.1092 pd=1.36 as=0.0441 ps=0.63 w=0.42 l=0.15
X39 VGND CLK a_643_369# VNB sky130_fd_pr__nfet_01v8 ad=0.0567 pd=0.69 as=0.1092 ps=1.36 w=0.42 l=0.15
X40 a_1770_295# a_1587_329# VGND VNB sky130_fd_pr__nfet_01v8 ad=0.1092 pd=1.36 as=0.08505 ps=0.825 w=0.42 l=0.15
X41 a_109_47# SCD VGND VNB sky130_fd_pr__nfet_01v8 ad=0.0441 pd=0.63 as=0.1092 ps=1.36 w=0.42 l=0.15
C0 VPB VNB 2.64247f
.ends

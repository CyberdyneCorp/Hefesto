* NGSPICE file created from sky130_fd_sc_hd__sdfbbp_1.ext - technology: sky130A

.subckt sky130_fd_sc_hd__sdfbbp_1 CLK D RESET_B SCD SCE SET_B VGND VNB VPB VPWR Q
+ Q_N
X0 a_381_363# SCD VPWR VPB sky130_fd_pr__pfet_01v8_hvt ad=0.0672 pd=0.85 as=0.1664 ps=1.8 w=0.64 l=0.15
X1 a_1107_21# SET_B VPWR VPB sky130_fd_pr__pfet_01v8_hvt ad=0.147 pd=1.23 as=0.0798 ps=0.8 w=0.42 l=0.15
X2 VPWR a_1400_21# a_2122_329# VPB sky130_fd_pr__pfet_01v8_hvt ad=0.2184 pd=2.2 as=0.0882 ps=1.05 w=0.84 l=0.15
X3 Q a_2596_47# VPWR VPB sky130_fd_pr__pfet_01v8_hvt ad=0.26 pd=2.52 as=0.149 ps=1.325 w=1 l=0.15
X4 a_931_47# a_193_47# a_453_363# VPB sky130_fd_pr__pfet_01v8_hvt ad=0.0567 pd=0.69 as=0.07035 ps=0.755 w=0.42 l=0.15
X5 VPWR a_1400_21# a_1351_329# VPB sky130_fd_pr__pfet_01v8_hvt ad=0.2247 pd=1.375 as=0.1134 ps=1.11 w=0.84 l=0.15
X6 a_1251_47# a_1400_21# a_1107_21# VNB sky130_fd_pr__nfet_01v8 ad=0.1664 pd=1.8 as=0.0864 ps=0.91 w=0.64 l=0.15
X7 VPWR SCE a_423_315# VPB sky130_fd_pr__pfet_01v8_hvt ad=0.0567 pd=0.69 as=0.1407 ps=1.51 w=0.42 l=0.15
X8 a_1351_329# a_931_47# a_1107_21# VPB sky130_fd_pr__pfet_01v8_hvt ad=0.1134 pd=1.11 as=0.147 ps=1.23 w=0.84 l=0.15
X9 VPWR RESET_B a_1400_21# VPB sky130_fd_pr__pfet_01v8_hvt ad=0.1539 pd=1.335 as=0.1664 ps=1.8 w=0.64 l=0.15
X10 VPWR CLK a_27_47# VPB sky130_fd_pr__pfet_01v8_hvt ad=0.0864 pd=0.91 as=0.1664 ps=1.8 w=0.64 l=0.15
X11 a_1572_329# a_1107_21# VPWR VPB sky130_fd_pr__pfet_01v8_hvt ad=0.1743 pd=1.41 as=0.2247 ps=1.375 w=0.84 l=0.15
X12 a_2122_329# a_1714_47# a_1887_21# VPB sky130_fd_pr__pfet_01v8_hvt ad=0.0882 pd=1.05 as=0.12285 ps=1.17 w=0.84 l=0.15
X13 a_2026_47# SET_B VGND VNB sky130_fd_pr__nfet_01v8 ad=0.09575 pd=0.965 as=0.08295 ps=0.815 w=0.42 l=0.15
X14 VGND a_1887_21# a_1822_47# VNB sky130_fd_pr__nfet_01v8 ad=0.08295 pd=0.815 as=0.066 ps=0.745 w=0.42 l=0.15
X15 a_1041_47# a_193_47# a_931_47# VNB sky130_fd_pr__special_nfet_01v8 ad=0.06705 pd=0.75 as=0.072 ps=0.76 w=0.36 l=0.15
X16 VPWR a_1107_21# a_1017_413# VPB sky130_fd_pr__pfet_01v8_hvt ad=0.0798 pd=0.8 as=0.0945 ps=0.87 w=0.42 l=0.15
X17 a_1107_21# a_931_47# a_1251_47# VNB sky130_fd_pr__nfet_01v8 ad=0.0864 pd=0.91 as=0.09575 ps=0.965 w=0.64 l=0.15
X18 VPWR a_1887_21# a_1800_413# VPB sky130_fd_pr__pfet_01v8_hvt ad=0.0819 pd=0.81 as=0.0924 ps=0.86 w=0.42 l=0.15
X19 a_764_47# a_423_315# VGND VNB sky130_fd_pr__nfet_01v8 ad=0.0441 pd=0.63 as=0.07245 ps=0.765 w=0.42 l=0.15
X20 a_1887_21# a_1714_47# a_2026_47# VNB sky130_fd_pr__nfet_01v8 ad=0.0864 pd=0.91 as=0.09575 ps=0.965 w=0.64 l=0.15
X21 a_1887_21# SET_B VPWR VPB sky130_fd_pr__pfet_01v8_hvt ad=0.12285 pd=1.17 as=0.0819 ps=0.81 w=0.42 l=0.15
X22 a_1800_413# a_193_47# a_1714_47# VPB sky130_fd_pr__pfet_01v8_hvt ad=0.0924 pd=0.86 as=0.0567 ps=0.69 w=0.42 l=0.15
X23 a_931_47# a_27_47# a_453_363# VNB sky130_fd_pr__special_nfet_01v8 ad=0.072 pd=0.76 as=0.066 ps=0.745 w=0.36 l=0.15
X24 a_193_47# a_27_47# VGND VNB sky130_fd_pr__nfet_01v8 ad=0.1092 pd=1.36 as=0.0567 ps=0.69 w=0.42 l=0.15
X25 a_453_363# D a_764_47# VNB sky130_fd_pr__nfet_01v8 ad=0.066 pd=0.745 as=0.0441 ps=0.63 w=0.42 l=0.15
X26 VGND SCE a_423_315# VNB sky130_fd_pr__nfet_01v8 ad=0.07245 pd=0.765 as=0.1092 ps=1.36 w=0.42 l=0.15
X27 a_1714_47# a_27_47# a_1572_329# VPB sky130_fd_pr__pfet_01v8_hvt ad=0.0567 pd=0.69 as=0.1743 ps=1.41 w=0.42 l=0.15
X28 VGND a_1107_21# a_1041_47# VNB sky130_fd_pr__nfet_01v8 ad=0.0882 pd=0.84 as=0.06705 ps=0.75 w=0.42 l=0.15
X29 a_2026_47# a_1400_21# a_1887_21# VNB sky130_fd_pr__nfet_01v8 ad=0.1664 pd=1.8 as=0.0864 ps=0.91 w=0.64 l=0.15
X30 Q a_2596_47# VGND VNB sky130_fd_pr__nfet_01v8 ad=0.169 pd=1.82 as=0.097 ps=0.975 w=0.65 l=0.15
X31 VGND a_1887_21# a_2596_47# VNB sky130_fd_pr__nfet_01v8 ad=0.097 pd=0.975 as=0.1092 ps=1.36 w=0.42 l=0.15
X32 a_193_47# a_27_47# VPWR VPB sky130_fd_pr__pfet_01v8_hvt ad=0.1664 pd=1.8 as=0.0864 ps=0.91 w=0.64 l=0.15
X33 a_1017_413# a_27_47# a_931_47# VPB sky130_fd_pr__pfet_01v8_hvt ad=0.0945 pd=0.87 as=0.0567 ps=0.69 w=0.42 l=0.15
X34 a_453_363# SCE a_381_47# VNB sky130_fd_pr__nfet_01v8 ad=0.1113 pd=1.37 as=0.0504 ps=0.66 w=0.42 l=0.15
X35 VPWR a_1887_21# a_2596_47# VPB sky130_fd_pr__pfet_01v8_hvt ad=0.149 pd=1.325 as=0.1664 ps=1.8 w=0.64 l=0.15
X36 a_453_363# a_423_315# a_381_363# VPB sky130_fd_pr__pfet_01v8_hvt ad=0.1664 pd=1.8 as=0.0672 ps=0.85 w=0.64 l=0.15
X37 a_381_47# SCD VGND VNB sky130_fd_pr__nfet_01v8 ad=0.0504 pd=0.66 as=0.1092 ps=1.36 w=0.42 l=0.15
X38 a_1822_47# a_27_47# a_1714_47# VNB sky130_fd_pr__special_nfet_01v8 ad=0.066 pd=0.745 as=0.0702 ps=0.75 w=0.36 l=0.15
X39 Q_N a_1887_21# VGND VNB sky130_fd_pr__nfet_01v8 ad=0.169 pd=1.82 as=0.10025 ps=0.985 w=0.65 l=0.15
X40 Q_N a_1887_21# VPWR VPB sky130_fd_pr__pfet_01v8_hvt ad=0.26 pd=2.52 as=0.1539 ps=1.335 w=1 l=0.15
X41 a_1714_47# a_193_47# a_1618_47# VNB sky130_fd_pr__special_nfet_01v8 ad=0.0702 pd=0.75 as=0.0944 ps=0.97 w=0.36 l=0.15
X42 a_453_363# D a_752_413# VPB sky130_fd_pr__pfet_01v8_hvt ad=0.07035 pd=0.755 as=0.0567 ps=0.69 w=0.42 l=0.15
X43 a_1251_47# SET_B VGND VNB sky130_fd_pr__nfet_01v8 ad=0.09575 pd=0.965 as=0.0882 ps=0.84 w=0.42 l=0.15
X44 a_1618_47# a_1107_21# VGND VNB sky130_fd_pr__nfet_01v8 ad=0.0944 pd=0.97 as=0.1664 ps=1.8 w=0.64 l=0.15
X45 a_752_413# SCE VPWR VPB sky130_fd_pr__pfet_01v8_hvt ad=0.0567 pd=0.69 as=0.0567 ps=0.69 w=0.42 l=0.15
X46 VGND CLK a_27_47# VNB sky130_fd_pr__nfet_01v8 ad=0.0567 pd=0.69 as=0.1092 ps=1.36 w=0.42 l=0.15
X47 VGND RESET_B a_1400_21# VNB sky130_fd_pr__nfet_01v8 ad=0.10025 pd=0.985 as=0.1092 ps=1.36 w=0.42 l=0.15
C0 VPB VNB 2.81966f
.ends

* NGSPICE file created from sky130_fd_sc_hd__maj3_4.ext - technology: sky130A

.subckt sky130_fd_sc_hd__maj3_4 A B C VGND VNB VPB VPWR X
X0 X a_47_297# VGND VNB sky130_fd_pr__nfet_01v8 ad=0.08775 pd=0.92 as=0.15763 ps=1.135 w=0.65 l=0.15
X1 a_151_297# C a_47_297# VPB sky130_fd_pr__pfet_01v8_hvt ad=0.1225 pd=1.245 as=0.37 ps=2.74 w=1 l=0.15
X2 VPWR A a_151_297# VPB sky130_fd_pr__pfet_01v8_hvt ad=0.135 pd=1.27 as=0.1225 ps=1.245 w=1 l=0.15
X3 VGND A a_151_47# VNB sky130_fd_pr__nfet_01v8 ad=0.08775 pd=0.92 as=0.07963 ps=0.895 w=0.65 l=0.15
X4 VGND a_47_297# X VNB sky130_fd_pr__nfet_01v8 ad=0.08775 pd=0.92 as=0.08775 ps=0.92 w=0.65 l=0.15
X5 VGND a_47_297# X VNB sky130_fd_pr__nfet_01v8 ad=0.169 pd=1.82 as=0.08775 ps=0.92 w=0.65 l=0.15
X6 VPWR C a_482_297# VPB sky130_fd_pr__pfet_01v8_hvt ad=0.2425 pd=1.485 as=0.105 ps=1.21 w=1 l=0.15
X7 a_314_47# A VGND VNB sky130_fd_pr__nfet_01v8 ad=0.08775 pd=0.92 as=0.08775 ps=0.92 w=0.65 l=0.15
X8 a_482_47# B a_47_297# VNB sky130_fd_pr__nfet_01v8 ad=0.06825 pd=0.86 as=0.08775 ps=0.92 w=0.65 l=0.15
X9 X a_47_297# VGND VNB sky130_fd_pr__nfet_01v8 ad=0.08775 pd=0.92 as=0.08775 ps=0.92 w=0.65 l=0.15
X10 VPWR a_47_297# X VPB sky130_fd_pr__pfet_01v8_hvt ad=0.26 pd=2.52 as=0.135 ps=1.27 w=1 l=0.15
X11 a_482_297# B a_47_297# VPB sky130_fd_pr__pfet_01v8_hvt ad=0.105 pd=1.21 as=0.135 ps=1.27 w=1 l=0.15
X12 VGND C a_482_47# VNB sky130_fd_pr__nfet_01v8 ad=0.15763 pd=1.135 as=0.06825 ps=0.86 w=0.65 l=0.15
X13 X a_47_297# VPWR VPB sky130_fd_pr__pfet_01v8_hvt ad=0.135 pd=1.27 as=0.135 ps=1.27 w=1 l=0.15
X14 a_47_297# B a_314_297# VPB sky130_fd_pr__pfet_01v8_hvt ad=0.135 pd=1.27 as=0.135 ps=1.27 w=1 l=0.15
X15 VPWR a_47_297# X VPB sky130_fd_pr__pfet_01v8_hvt ad=0.135 pd=1.27 as=0.135 ps=1.27 w=1 l=0.15
X16 a_47_297# B a_314_47# VNB sky130_fd_pr__nfet_01v8 ad=0.08775 pd=0.92 as=0.08775 ps=0.92 w=0.65 l=0.15
X17 a_314_297# A VPWR VPB sky130_fd_pr__pfet_01v8_hvt ad=0.135 pd=1.27 as=0.135 ps=1.27 w=1 l=0.15
X18 a_151_47# C a_47_297# VNB sky130_fd_pr__nfet_01v8 ad=0.07963 pd=0.895 as=0.182 ps=1.86 w=0.65 l=0.15
X19 X a_47_297# VPWR VPB sky130_fd_pr__pfet_01v8_hvt ad=0.135 pd=1.27 as=0.2425 ps=1.485 w=1 l=0.15
.ends

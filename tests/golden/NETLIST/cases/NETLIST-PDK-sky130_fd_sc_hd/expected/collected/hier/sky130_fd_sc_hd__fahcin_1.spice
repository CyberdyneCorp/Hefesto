* NGSPICE file created from sky130_fd_sc_hd__fahcin_1.ext - technology: sky130A

.subckt sky130_fd_sc_hd__fahcin_1 A B CIN VGND VNB VPB VPWR COUT SUM
X0 a_721_47# a_489_21# a_27_47# VPB sky130_fd_pr__pfet_01v8_hvt ad=0.15225 pd=1.3 as=0.3398 ps=2.77 w=0.84 l=0.15
X1 VGND a_1636_315# a_1565_49# VNB sky130_fd_pr__nfet_01v8 ad=0.10525 pd=0.975 as=0.1728 ps=1.82 w=0.64 l=0.15
X2 SUM a_1647_49# VPWR VPB sky130_fd_pr__pfet_01v8_hvt ad=0.285 pd=2.57 as=0.135 ps=1.27 w=1 l=0.15
X3 VGND CIN a_1251_49# VNB sky130_fd_pr__nfet_01v8 ad=0.10525 pd=0.975 as=0.1664 ps=1.8 w=0.64 l=0.15
X4 VPWR a_67_199# a_27_47# VPB sky130_fd_pr__pfet_01v8_hvt ad=0.175 pd=1.35 as=0.265 ps=2.53 w=1 l=0.15
X5 a_67_199# B a_721_47# VPB sky130_fd_pr__pfet_01v8_hvt ad=0.2814 pd=2.35 as=0.15225 ps=1.3 w=0.84 l=0.15
X6 VPWR CIN a_1251_49# VPB sky130_fd_pr__pfet_01v8_hvt ad=0.135 pd=1.27 as=0.26 ps=2.52 w=1 l=0.15
X7 a_67_199# a_489_21# a_434_49# VPB sky130_fd_pr__pfet_01v8_hvt ad=0.2184 pd=2.2 as=0.1155 ps=1.115 w=0.84 l=0.15
X8 COUT a_434_49# a_1251_49# VNB sky130_fd_pr__nfet_01v8 ad=0.088 pd=0.915 as=0.192 ps=1.88 w=0.64 l=0.15
X9 a_1647_49# a_721_47# a_1565_49# VNB sky130_fd_pr__nfet_01v8 ad=0.0928 pd=0.93 as=0.1664 ps=1.8 w=0.64 l=0.15
X10 a_434_49# B a_67_199# VNB sky130_fd_pr__nfet_01v8 ad=0.088 pd=0.915 as=0.32122 ps=1.645 w=0.64 l=0.15
X11 a_434_49# B a_27_47# VPB sky130_fd_pr__pfet_01v8_hvt ad=0.1155 pd=1.115 as=0.2629 ps=2.64 w=0.84 l=0.15
X12 VPWR a_1636_315# a_1565_49# VPB sky130_fd_pr__pfet_01v8_hvt ad=0.135 pd=1.27 as=0.4492 ps=1.98 w=1 l=0.15
X13 VGND B a_489_21# VNB sky130_fd_pr__nfet_01v8 ad=0.11645 pd=1.01 as=0.16533 ps=1.82 w=0.65 l=0.15
X14 SUM a_1647_49# VGND VNB sky130_fd_pr__nfet_01v8 ad=0.18525 pd=1.87 as=0.10525 ps=0.975 w=0.65 l=0.15
X15 a_67_199# A VPWR VPB sky130_fd_pr__pfet_01v8_hvt ad=0.31175 pd=2.88 as=0.175 ps=1.35 w=1 l=0.15
X16 a_1142_49# a_721_47# COUT VNB sky130_fd_pr__nfet_01v8 ad=0.1792 pd=1.84 as=0.088 ps=0.915 w=0.64 l=0.15
X17 VGND a_67_199# a_27_47# VNB sky130_fd_pr__nfet_01v8 ad=0.10525 pd=0.975 as=0.1696 ps=1.81 w=0.64 l=0.15
X18 a_27_47# a_489_21# a_434_49# VNB sky130_fd_pr__nfet_01v8 ad=0.19983 pd=1.91 as=0.088 ps=0.915 w=0.64 l=0.15
X19 a_67_199# A VGND VNB sky130_fd_pr__nfet_01v8 ad=0.32122 pd=1.645 as=0.10525 ps=0.975 w=0.65 l=0.15
X20 VPWR B a_489_21# VPB sky130_fd_pr__pfet_01v8_hvt ad=0.18 pd=1.36 as=0.26 ps=2.52 w=1 l=0.15
X21 a_27_47# B a_721_47# VNB sky130_fd_pr__nfet_01v8 ad=0.16283 pd=1.8 as=0.16567 ps=1.165 w=0.64 l=0.15
X22 a_1251_49# a_721_47# COUT VPB sky130_fd_pr__pfet_01v8_hvt ad=0.7033 pd=3.36 as=0.1134 ps=1.11 w=0.84 l=0.15
X23 a_1142_49# a_489_21# VGND VNB sky130_fd_pr__nfet_01v8 ad=0.1664 pd=1.8 as=0.11645 ps=1.01 w=0.64 l=0.15
X24 a_1142_49# a_489_21# VPWR VPB sky130_fd_pr__pfet_01v8_hvt ad=0.3826 pd=1.79 as=0.18 ps=1.36 w=1 l=0.15
X25 a_1565_49# a_434_49# a_1647_49# VPB sky130_fd_pr__pfet_01v8_hvt ad=0.4492 pd=1.98 as=0.1134 ps=1.11 w=0.84 l=0.15
X26 a_721_47# a_489_21# a_67_199# VNB sky130_fd_pr__nfet_01v8 ad=0.16567 pd=1.165 as=0.16813 ps=1.83 w=0.64 l=0.15
X27 a_1636_315# a_434_49# a_1647_49# VNB sky130_fd_pr__nfet_01v8 ad=0.4768 pd=2.77 as=0.0928 ps=0.93 w=0.64 l=0.15
X28 a_1647_49# a_721_47# a_1636_315# VPB sky130_fd_pr__pfet_01v8_hvt ad=0.1134 pd=1.11 as=0.2184 ps=2.2 w=0.84 l=0.15
X29 a_1636_315# CIN VPWR VPB sky130_fd_pr__pfet_01v8_hvt ad=0.265 pd=2.53 as=0.135 ps=1.27 w=1 l=0.15
X30 COUT a_434_49# a_1142_49# VPB sky130_fd_pr__pfet_01v8_hvt ad=0.1134 pd=1.11 as=0.3826 ps=1.79 w=0.84 l=0.15
X31 a_1636_315# CIN VGND VNB sky130_fd_pr__nfet_01v8 ad=0.169 pd=1.82 as=0.10525 ps=0.975 w=0.65 l=0.15
C0 VPB VNB 2.46528f
.ends

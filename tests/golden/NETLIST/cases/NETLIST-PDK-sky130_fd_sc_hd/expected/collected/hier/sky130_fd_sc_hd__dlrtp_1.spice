* NGSPICE file created from sky130_fd_sc_hd__dlrtp_1.ext - technology: sky130A

.subckt sky130_fd_sc_hd__dlrtp_1 D GATE RESET_B VGND VNB VPB VPWR Q
X0 a_929_47# a_560_425# a_711_21# VNB sky130_fd_pr__nfet_01v8 ad=0.10725 pd=0.98 as=0.169 ps=1.82 w=0.65 l=0.15
X1 VPWR D a_299_47# VPB sky130_fd_pr__pfet_01v8_hvt ad=0.0864 pd=0.91 as=0.1664 ps=1.8 w=0.64 l=0.15
X2 Q a_711_21# VPWR VPB sky130_fd_pr__pfet_01v8_hvt ad=0.26 pd=2.52 as=0.155 ps=1.31 w=1 l=0.15
X3 a_465_47# a_299_47# VGND VNB sky130_fd_pr__nfet_01v8 ad=0.07665 pd=0.785 as=0.0567 ps=0.69 w=0.42 l=0.15
X4 VGND a_711_21# a_654_47# VNB sky130_fd_pr__nfet_01v8 ad=0.1092 pd=1.36 as=0.05985 ps=0.705 w=0.42 l=0.15
X5 VPWR GATE a_27_47# VPB sky130_fd_pr__pfet_01v8_hvt ad=0.0864 pd=0.91 as=0.1664 ps=1.8 w=0.64 l=0.15
X6 Q a_711_21# VGND VNB sky130_fd_pr__nfet_01v8 ad=0.169 pd=1.82 as=0.10075 ps=0.96 w=0.65 l=0.15
X7 a_560_425# a_27_47# a_465_369# VPB sky130_fd_pr__special_pfet_01v8_hvt ad=0.0666 pd=0.73 as=0.0935 ps=0.965 w=0.36 l=0.15
X8 VPWR a_711_21# a_664_425# VPB sky130_fd_pr__pfet_01v8_hvt ad=0.2006 pd=1.61 as=0.0822 ps=0.835 w=0.42 l=0.15
X9 a_654_47# a_27_47# a_560_425# VNB sky130_fd_pr__nfet_01v8 ad=0.05985 pd=0.705 as=0.0588 ps=0.7 w=0.42 l=0.15
X10 a_193_47# a_27_47# VGND VNB sky130_fd_pr__nfet_01v8 ad=0.1092 pd=1.36 as=0.0567 ps=0.69 w=0.42 l=0.15
X11 a_711_21# a_560_425# VPWR VPB sky130_fd_pr__pfet_01v8_hvt ad=0.165 pd=1.33 as=0.2006 ps=1.61 w=1 l=0.15
X12 VPWR RESET_B a_711_21# VPB sky130_fd_pr__pfet_01v8_hvt ad=0.155 pd=1.31 as=0.165 ps=1.33 w=1 l=0.15
X13 a_193_47# a_27_47# VPWR VPB sky130_fd_pr__pfet_01v8_hvt ad=0.1664 pd=1.8 as=0.0864 ps=0.91 w=0.64 l=0.15
X14 a_560_425# a_193_47# a_465_47# VNB sky130_fd_pr__nfet_01v8 ad=0.0588 pd=0.7 as=0.07665 ps=0.785 w=0.42 l=0.15
X15 a_664_425# a_193_47# a_560_425# VPB sky130_fd_pr__special_pfet_01v8_hvt ad=0.0822 pd=0.835 as=0.0666 ps=0.73 w=0.36 l=0.15
X16 VGND D a_299_47# VNB sky130_fd_pr__nfet_01v8 ad=0.0567 pd=0.69 as=0.1092 ps=1.36 w=0.42 l=0.15
X17 VGND RESET_B a_929_47# VNB sky130_fd_pr__nfet_01v8 ad=0.10075 pd=0.96 as=0.10725 ps=0.98 w=0.65 l=0.15
X18 a_465_369# a_299_47# VPWR VPB sky130_fd_pr__pfet_01v8_hvt ad=0.0935 pd=0.965 as=0.0864 ps=0.91 w=0.64 l=0.15
X19 VGND GATE a_27_47# VNB sky130_fd_pr__nfet_01v8 ad=0.0567 pd=0.69 as=0.1092 ps=1.36 w=0.42 l=0.15
.ends

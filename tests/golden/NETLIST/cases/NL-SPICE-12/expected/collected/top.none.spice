* SPICE3 file created from top.ext - technology: nltest

.option scale=10n

M1000 d g s GND nfet w=8 l=2
+  ad=30p pd=16u as=40p ps=26u
M1001 s g d GND nfet w=8 l=2
+  ad=0 pd=0 as=0 ps=0
C0 ct cb 10f
M1002 d g s GND nfet w=8 l=2
+  ad=0 pd=0 as=0 ps=0
C1 ct cb 5f
M1003 d g s GND nfet w=4 l=2
+  ad=0 pd=0 as=0 ps=0
C2 ct cb 10f

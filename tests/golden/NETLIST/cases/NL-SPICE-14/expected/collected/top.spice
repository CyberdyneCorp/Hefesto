* SPICE3 file created from top.ext - technology: nltest

.option scale=10n

M1000 g g s VSUBS nfet w=4 l=2
+  ad=0 pd=0 as=0 ps=0
M1001 g g s well1 nfet w=4 l=2
+  ad=0 pd=0 as=0 ps=0

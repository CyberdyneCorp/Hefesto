* SPICE3 file created from top.ext - technology: nltest

.option scale=10n

.global VDD GND

.subckt leaf in n5
M1000 n6 in n5 GND nfet w=4 l=2
+  ad=0 pd=0 as=0 ps=0
.ends

* Top level circuit top

Xu1 u1/in a leaf
.end

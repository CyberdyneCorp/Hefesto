* b
.subckt top a b
X1 a b cdev v=0
X2 b a cdev v=-1
.ends
.subckt cdev p n
.ends

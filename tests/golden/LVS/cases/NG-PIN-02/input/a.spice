.subckt top A Y
R1 A Y 1k
R2 A Y 2k
.ends

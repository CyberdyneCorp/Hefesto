* placeholder device
.subckt top a b
X1 a b cdev w=1 l=2 mult=1
.ends
.subckt cdev p n
.ends

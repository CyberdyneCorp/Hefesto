* subcircuits
.subckt pa a b PARAMS: w=1 l=2
R1 a b 1k
.ends
.ends
.subckt noport
R1 x y 1k
.ends
.subckt outer a b
.subckt inner c d
R1 c d 1
.ends
X1 a b inner
.ends
.subckt last a
R1 a 0 1k

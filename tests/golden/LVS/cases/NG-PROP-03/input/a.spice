* dev
.subckt top d g s b
M1 d g s b nmos W=1u L=0.15u M=1 AS=1p
.ends

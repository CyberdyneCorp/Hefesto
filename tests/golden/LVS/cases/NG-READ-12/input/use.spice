* user
.subckt top a b
X1 a b cellA
.ends

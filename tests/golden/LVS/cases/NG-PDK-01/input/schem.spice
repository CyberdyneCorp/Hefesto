* inv schematic netlist
.subckt inv A Y VPWR VGND VPB VNB
XM1 Y A VGND VNB sky130_fd_pr__nfet_01v8 L=0.15 W=0.65 nf=1 mult=1 m=1
XM2 Y A VPWR VPB sky130_fd_pr__pfet_01v8_hvt L=0.15 W=1 nf=1 mult=1 m=1
.ends

* merged
.subckt top a c
R2 a c 1k
.ends

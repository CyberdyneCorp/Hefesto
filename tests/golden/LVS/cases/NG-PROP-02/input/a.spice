* a
.subckt top a b
X1 a b cdev nf=2 model=abcde
.ends
.subckt cdev p n
.ends

.subckt inv A Y VDD
M1 Y A VDD VDD pmos W=2u L=0.15u
.ends
.subckt top A Y VDD
X1 A Y VDD inv
.ends

.global VDD
.subckt inv A Y
M1 Y A VDD VDD pmos W=2u L=0.15u
.ends
.subckt top A Y VDD
X1 A Y inv
.ends

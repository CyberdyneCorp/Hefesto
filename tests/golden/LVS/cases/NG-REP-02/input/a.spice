* inverter with an extra nmos
.subckt inv A Y VDD VSS
M1 Y A VSS VSS nmos W=1u L=0.15u
M2 Y A VDD VDD pmos W=2u L=0.15u
M3 Y A VSS VSS nmos W=1u L=0.15u
.ends

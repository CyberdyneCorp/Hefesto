.subckt adc in out
.ends
.subckt top a b
X1 a b adc
.ends

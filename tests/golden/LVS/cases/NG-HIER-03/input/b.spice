* inverter
.subckt inv A Y VDD VSS
M1 Y A VSS VSS nmos W=1u L=0.15u
M2 Y A VDD VDD pmos W=2u L=0.15u
.ends
.subckt top A Y VDD VSS
X1 A m1 VDD VSS inv
X2 m1 m VDD VSS inv
X3 m m2 VDD VSS inv
X4 m2 Y VDD VSS inv
.ends

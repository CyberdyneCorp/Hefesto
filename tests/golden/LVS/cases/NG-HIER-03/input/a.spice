* inverter
.subckt inv A Y VDD VSS
M1 Y A VSS VSS nmos W=1u L=0.15u
M2 Y A VDD VDD pmos W=2u L=0.15u
.ends
.subckt pair A Y VDD VSS
X1 A m VDD VSS inv
X2 m Y VDD VSS inv
.ends
.subckt top A Y VDD VSS
X1 A m VDD VSS pair
X2 m Y VDD VSS pair
.ends

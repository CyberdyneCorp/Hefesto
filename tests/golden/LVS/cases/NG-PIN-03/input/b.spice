.subckt sub A Y B
R1 A Y 1k
.ends
.subckt top a y b
X1 a y b sub
.ends

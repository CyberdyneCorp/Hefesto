.subckt sub A Y
R1 A Y 1k
.ends
.subckt top a y b
X1 a y sub
.ends

* placeholder device
.subckt top a b
X1 a b cdev
.ends
.subckt cdev p n
.ends

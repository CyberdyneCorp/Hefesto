* b
.subckt top a b
X1 a b r1 w=1 l=2 M=2 S=2
.ends
.subckt r1 p n
.ends

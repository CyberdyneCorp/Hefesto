.subckt sub A B Y
R1 A Y 1k
R2 B Y 1k
.ends
.subckt top a y
X1 a a y sub
.ends

* two-input NAND
.subckt nand2 A B Y VDD VSS
M1 Y B n1 VSS nmos W=1u L=0.15u
M2 n1 A VSS VSS nmos W=1u L=0.15u
M3 Y A VDD VDD pmos W=1u L=0.15u
M4 Y B VDD VDD pmos W=1u L=0.15u
.ends

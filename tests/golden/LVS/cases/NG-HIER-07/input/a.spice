.subckt buf A Y1 Y2
R1 A Y1 1k
R2 Y1 Y2 0
.ends
.subckt top a y
X1 a y y buf
.ends

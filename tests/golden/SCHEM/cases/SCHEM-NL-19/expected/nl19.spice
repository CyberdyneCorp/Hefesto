** sch_path: /work/input/nl19.sch
**.subckt nl19
R1 net1 DATA[3] 1
R2 net2 DATA2 2
R3 net3 SPARE 3
R4[1] net4_1 ADDR[5] 4
R4[0] net4_0 ADDR[4] 4
R5 net5 ADDR[0] 5
**.ends
.end

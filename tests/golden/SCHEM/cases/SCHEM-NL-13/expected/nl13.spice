** sch_path: /work/input/nl13.sch
**.subckt nl13
R1 net1 net2 2
R2 net3 net4 1
R3 net5 net6 0.001
R4 net7 net8 150n
R5 net9 net10 W_N*2
R6 net11 net12 0.29
R7 net13 net14 123.5k
R8 net15 net16 inf
**.ends
.end

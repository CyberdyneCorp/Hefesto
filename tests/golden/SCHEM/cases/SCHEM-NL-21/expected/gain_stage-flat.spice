** GAIN_STAGE flat netlist
*.IPIN IN
*.IPIN VSS
*.IPIN VCC
*.OPIN OUT
*.IPIN START
*.IPIN START_N
*.IPIN EN_N
C5 OUT 0 4F
*--------BEGIN_XM6->SKY130_FD_PR__
XM6 OUT IN NET1 VSS  SKY130_FD_PR__ L=1 W=WN NF=1 AD='INT((1+1)/2)*WN/1*0.29' AS='INT((1+2)/2)*WN/1*0.29' PD='2*INT((1+1)/2)*(WN/1+0.29)'
+ PS='2*INT((1+2)/2)*(WN/1+0.29)' NRD='0.29/WN' NRS='0.29/WN' SA=0 SB=0 SD=0 MULT=1
*--------END___XM6->SKY130_FD_PR__
V4 NET1 VSS 0
.SAVE I(V4)
*--------BEGIN_XM7->SKY130_FD_PR__NFET_01V8
XM7 OUT EN_N VSS VSS  SKY130_FD_PR__NFET_01V8 L=0.15 W=0.5 NF=1 AD=0.145 AS=0.145 PD=1.58 PS=1.58 NRD=0.58 NRS=0.58 SA=0 SB=0 SD=0
+ MULT=3 M=3
*--------END___XM7->SKY130_FD_PR__NFET_01V8
*--------BEGIN_XM46->SKY130_FD_PR__PFET_01V8
XM46 NET6 EN_N VCC VCC  SKY130_FD_PR__PFET_01V8 L=0.15 W=5 NF=1 AD=1.45 AS=1.45 PD=10.58 PS=10.58 NRD=0.058 NRS=0.058 SA=0 SB=0
+ SD=0 MULT=1
*--------END___XM46->SKY130_FD_PR__PFET_01V8
V17 NET6 NET2 0
.SAVE I(V17)
*--------BEGIN_XM5->SKY130_FD_PR__PFET_01V8_LVT
XM5 OUT IN NET2 VCC  SKY130_FD_PR__PFET_01V8_LVT L=1 W=WP NF=1 AD='INT((1+1)/2)*WP/1*0.29' AS='INT((1+2)/2)*WP/1*0.29' PD='2*INT((1+1)/2)*(WP/1+0.29)'
+ PS='2*INT((1+2)/2)*(WP/1+0.29)' NRD='0.29/WP' NRS='0.29/WP' SA=0 SB=0 SD=0 MULT=1
*--------END___XM5->SKY130_FD_PR__PFET_01V8_LVT
*--------BEGIN_XM8->SKY130_FD_PR__PFET_01V8_LVT
XM8 NET4 ADJ NET3 VCC  SKY130_FD_PR__PFET_01V8_LVT L=1 W=WP NF=1 AD='INT((1+1)/2)*WP/1*0.29' AS='INT((1+2)/2)*WP/1*0.29' PD='2*INT((1+1)/2)*(WP/1+0.29)'
+ PS='2*INT((1+2)/2)*(WP/1+0.29)' NRD='0.29/WP' NRS='0.29/WP' SA=0 SB=0 SD=0 MULT=1
*--------END___XM8->SKY130_FD_PR__PFET_01V8_LVT
*--------BEGIN_XM9->SKY130_FD_PR__
XM9 NET4 ADJ NET5 VSS  SKY130_FD_PR__ L=1 W=WN NF=1 AD='INT((1+1)/2)*WN/1*0.29' AS='INT((1+2)/2)*WN/1*0.29' PD='2*INT((1+1)/2)*(WN/1+0.29)'
+ PS='2*INT((1+2)/2)*(WN/1+0.29)' NRD='0.29/WN' NRS='0.29/WN' SA=0 SB=0 SD=0 MULT=1
*--------END___XM9->SKY130_FD_PR__
*--------BEGIN_XM10->SKY130_FD_PR__NFET_01V8
XM10 NET5 VCC VSS VSS  SKY130_FD_PR__NFET_01V8 L=4 W=WN NF=1 AD='INT((1+1)/2)*WN/1*0.29' AS='INT((1+2)/2)*WN/1*0.29' PD='2*INT((1+1)/2)*(WN/1+0.29)'
+ PS='2*INT((1+2)/2)*(WN/1+0.29)' NRD='0.29/WN' NRS='0.29/WN' SA=0 SB=0 SD=0 MULT=1
*--------END___XM10->SKY130_FD_PR__NFET_01V8
*--------BEGIN_XM1->SKY130_FD_PR__PFET_01V8
XM1 NET3 EN_N VCC VCC  SKY130_FD_PR__PFET_01V8 L=4 W=WP NF=1 AD='INT((1+1)/2)*WP/1*0.29' AS='INT((1+2)/2)*WP/1*0.29' PD='2*INT((1+1)/2)*(WP/1+0.29)'
+ PS='2*INT((1+2)/2)*(WP/1+0.29)' NRD='0.29/WP' NRS='0.29/WP' SA=0 SB=0 SD=0 MULT=1
*--------END___XM1->SKY130_FD_PR__PFET_01V8
C1 IN 0 4F
*--------BEGIN_X6->PASSGATE_1

*.IOPIN A
*.IOPIN Z
*.IPIN GP
*.IPIN GN
*--------BEGIN_X6_XM1->SKY130_FD_PR__NFET_01V8
XM1_X6 ADJ START_N OUT VSS  SKY130_FD_PR__NFET_01V8 L=0.35 W=0.42 NF=1 AD='INT((1+1)/2)*W_N/1*0.29' AS='INT((1+2)/2)*W_N/1*0.29' PD='2*INT((1+1)/2)*(W_N/1+0.29)'
+ PS='2*INT((1+2)/2)*(W_N/1+0.29)' NRD='0.29/W_N' NRS='0.29/W_N' SA=0 SB=0 SD=0 MULT=1
*--------END___X6_XM1->SKY130_FD_PR__NFET_01V8
*--------BEGIN_X6_XM2->SKY130_FD_PR__PFET_01V8_LVT
XM2_X6 ADJ START OUT VCC  SKY130_FD_PR__PFET_01V8_LVT L=0.35 W=0.6 NF=1 AD='INT((1+1)/2)*W_P/1*0.29' AS='INT((1+2)/2)*W_P/1*0.29' PD='2*INT((1+1)/2)*(W_P/1+0.29)'
+ PS='2*INT((1+2)/2)*(W_P/1+0.29)' NRD='0.29/W_P' NRS='0.29/W_P' SA=0 SB=0 SD=0 MULT=1
*--------END___X6_XM2->SKY130_FD_PR__PFET_01V8_LVT
* NOCONN VCCBPIN
* NOCONN VSSBPIN
*--------END___X6->PASSGATE_1
*--------BEGIN_XC2->SKY130_FD_PR__CAP_MIM_M3_2
XC2 ADJ VSS  SKY130_FD_PR__CAP_MIM_M3_2 W=WCAP L=WCAP MF=2 M=2
*--------END___XC2->SKY130_FD_PR__CAP_MIM_M3_2
V1 NET4 OUT 0
.SAVE I(V1)
.end

** TOP flat netlist
*.IPIN CLK
*.IPIN RESET
*--------BEGIN_XMIPS_INST->MIPS
*.IPIN CLK
*.OPIN
*+ IMEM_ADDR[31],IMEM_ADDR[30],IMEM_ADDR[29],IMEM_ADDR[28],IMEM_ADDR[27],IMEM_ADDR[26],IMEM_ADDR[25],IMEM_ADDR[24],IMEM_ADDR[23],IMEM_ADDR[22],IMEM_ADDR[21],IMEM_ADDR[20],IMEM_ADDR[19],IMEM_ADDR[18],IMEM_ADDR[17],IMEM_ADDR[16],IMEM_ADDR[15],IMEM_ADDR[14],IMEM_ADDR[13],IMEM_ADDR[12],IMEM_ADDR[11],IMEM_ADDR[10],IMEM_ADDR[9],IMEM_ADDR[8],IMEM_ADDR[7],IMEM_ADDR[6],IMEM_ADDR[5],IMEM_ADDR[4],IMEM_ADDR[3],IMEM_ADDR[2],IMEM_ADDR[1],IMEM_ADDR[0]
*.IPIN RST
*.IPIN
*+ IMEM_DATA[31],IMEM_DATA[30],IMEM_DATA[29],IMEM_DATA[28],IMEM_DATA[27],IMEM_DATA[26],IMEM_DATA[25],IMEM_DATA[24],IMEM_DATA[23],IMEM_DATA[22],IMEM_DATA[21],IMEM_DATA[20],IMEM_DATA[19],IMEM_DATA[18],IMEM_DATA[17],IMEM_DATA[16],IMEM_DATA[15],IMEM_DATA[14],IMEM_DATA[13],IMEM_DATA[12],IMEM_DATA[11],IMEM_DATA[10],IMEM_DATA[9],IMEM_DATA[8],IMEM_DATA[7],IMEM_DATA[6],IMEM_DATA[5],IMEM_DATA[4],IMEM_DATA[3],IMEM_DATA[2],IMEM_DATA[1],IMEM_DATA[0]
*.IPIN
*+ DMEM_RDATA[31],DMEM_RDATA[30],DMEM_RDATA[29],DMEM_RDATA[28],DMEM_RDATA[27],DMEM_RDATA[26],DMEM_RDATA[25],DMEM_RDATA[24],DMEM_RDATA[23],DMEM_RDATA[22],DMEM_RDATA[21],DMEM_RDATA[20],DMEM_RDATA[19],DMEM_RDATA[18],DMEM_RDATA[17],DMEM_RDATA[16],DMEM_RDATA[15],DMEM_RDATA[14],DMEM_RDATA[13],DMEM_RDATA[12],DMEM_RDATA[11],DMEM_RDATA[10],DMEM_RDATA[9],DMEM_RDATA[8],DMEM_RDATA[7],DMEM_RDATA[6],DMEM_RDATA[5],DMEM_RDATA[4],DMEM_RDATA[3],DMEM_RDATA[2],DMEM_RDATA[1],DMEM_RDATA[0]
*.OPIN DMEM_WE
*.OPIN
*+ DMEM_ADDR[31],DMEM_ADDR[30],DMEM_ADDR[29],DMEM_ADDR[28],DMEM_ADDR[27],DMEM_ADDR[26],DMEM_ADDR[25],DMEM_ADDR[24],DMEM_ADDR[23],DMEM_ADDR[22],DMEM_ADDR[21],DMEM_ADDR[20],DMEM_ADDR[19],DMEM_ADDR[18],DMEM_ADDR[17],DMEM_ADDR[16],DMEM_ADDR[15],DMEM_ADDR[14],DMEM_ADDR[13],DMEM_ADDR[12],DMEM_ADDR[11],DMEM_ADDR[10],DMEM_ADDR[9],DMEM_ADDR[8],DMEM_ADDR[7],DMEM_ADDR[6],DMEM_ADDR[5],DMEM_ADDR[4],DMEM_ADDR[3],DMEM_ADDR[2],DMEM_ADDR[1],DMEM_ADDR[0]
*.OPIN
*+ DMEM_WDATA[31],DMEM_WDATA[30],DMEM_WDATA[29],DMEM_WDATA[28],DMEM_WDATA[27],DMEM_WDATA[26],DMEM_WDATA[25],DMEM_WDATA[24],DMEM_WDATA[23],DMEM_WDATA[22],DMEM_WDATA[21],DMEM_WDATA[20],DMEM_WDATA[19],DMEM_WDATA[18],DMEM_WDATA[17],DMEM_WDATA[16],DMEM_WDATA[15],DMEM_WDATA[14],DMEM_WDATA[13],DMEM_WDATA[12],DMEM_WDATA[11],DMEM_WDATA[10],DMEM_WDATA[9],DMEM_WDATA[8],DMEM_WDATA[7],DMEM_WDATA[6],DMEM_WDATA[5],DMEM_WDATA[4],DMEM_WDATA[3],DMEM_WDATA[2],DMEM_WDATA[1],DMEM_WDATA[0]
*--------BEGIN_XMIPS_INST_XCONTROLLER_INST->CONTROLLER
*.IPIN
*+ INSTR[31],INSTR[30],INSTR[29],INSTR[28],INSTR[27],INSTR[26],INSTR[25],INSTR[24],INSTR[23],INSTR[22],INSTR[21],INSTR[20],INSTR[19],INSTR[18],INSTR[17],INSTR[16],INSTR[15],INSTR[14],INSTR[13],INSTR[12],INSTR[11],INSTR[10],INSTR[9],INSTR[8],INSTR[7],INSTR[6],INSTR[5],INSTR[4],INSTR[3],INSTR[2],INSTR[1],INSTR[0]
*.OPIN ALUCONTROL[2],ALUCONTROL[1],ALUCONTROL[0]
*.OPIN BRANCH
*.OPIN JUMP
*.OPIN MEM_TO_REG
*.OPIN MEM_WRITE
*.OPIN REG_DST
*.OPIN REG_WRITE
*.OPIN ALU_SRC
*--------BEGIN_XMIPS_INST_XCONTROLLER_INST_XMAINDEC_INST->MAINDEC
*.IPIN
*+ INSTR[31],INSTR[30],INSTR[29],INSTR[28],INSTR[27],INSTR[26],INSTR[25],INSTR[24],INSTR[23],INSTR[22],INSTR[21],INSTR[20],INSTR[19],INSTR[18],INSTR[17],INSTR[16],INSTR[15],INSTR[14],INSTR[13],INSTR[12],INSTR[11],INSTR[10],INSTR[9],INSTR[8],INSTR[7],INSTR[6],INSTR[5],INSTR[4],INSTR[3],INSTR[2],INSTR[1],INSTR[0]
*.OPIN BRANCH
*.OPIN JUMP
*.OPIN MEM_TO_REG
*.OPIN MEM_WRITE
*.OPIN REG_DST
*.OPIN REG_WRITE
*.OPIN ALU_SRC
* NOCONN BRANCH
* NOCONN JUMP
* NOCONN MEM_TO_REG
* NOCONN MEM_WRITE
* NOCONN REG_DST
* NOCONN REG_WRITE
* NOCONN ALU_SRC
* NOCONN INSTR[31:0]
*--------END___XMIPS_INST_XCONTROLLER_INST_XMAINDEC_INST->MAINDEC
*--------BEGIN_XMIPS_INST_XCONTROLLER_INST_XALUDEC_INST->ALUDEC
*.IPIN
*+ INSTR[31],INSTR[30],INSTR[29],INSTR[28],INSTR[27],INSTR[26],INSTR[25],INSTR[24],INSTR[23],INSTR[22],INSTR[21],INSTR[20],INSTR[19],INSTR[18],INSTR[17],INSTR[16],INSTR[15],INSTR[14],INSTR[13],INSTR[12],INSTR[11],INSTR[10],INSTR[9],INSTR[8],INSTR[7],INSTR[6],INSTR[5],INSTR[4],INSTR[3],INSTR[2],INSTR[1],INSTR[0]
*.OPIN ALUCONTROL[2],ALUCONTROL[1],ALUCONTROL[0]
* NOCONN ALUCONTROL[2:0]
* NOCONN INSTR[31:0]
*--------END___XMIPS_INST_XCONTROLLER_INST_XALUDEC_INST->ALUDEC
* NOCONN BRANCH
* NOCONN JUMP
* NOCONN MEM_TO_REG
* NOCONN MEM_WRITE
* NOCONN REG_DST
* NOCONN REG_WRITE
* NOCONN ALUCONTROL[2:0]
* NOCONN ALU_SRC
* NOCONN INSTR[31:0]
*--------END___XMIPS_INST_XCONTROLLER_INST->CONTROLLER
*--------BEGIN_XMIPS_INST_XDATAPATH_INST->DATAPATH
*.IPIN CLK
*.IPIN RST
*.IPIN ALUCONTROL[2],ALUCONTROL[1],ALUCONTROL[0]
*.IPIN ALU_SRC
*.IPIN BRANCH
*.IPIN JUMP
*.IPIN MEM_TO_REG
*.IPIN REG_DST
*.IPIN REG_WRITE
*.IPIN
*+ INSTR[31],INSTR[30],INSTR[29],INSTR[28],INSTR[27],INSTR[26],INSTR[25],INSTR[24],INSTR[23],INSTR[22],INSTR[21],INSTR[20],INSTR[19],INSTR[18],INSTR[17],INSTR[16],INSTR[15],INSTR[14],INSTR[13],INSTR[12],INSTR[11],INSTR[10],INSTR[9],INSTR[8],INSTR[7],INSTR[6],INSTR[5],INSTR[4],INSTR[3],INSTR[2],INSTR[1],INSTR[0]
*.OPIN
*+ PC[31],PC[30],PC[29],PC[28],PC[27],PC[26],PC[25],PC[24],PC[23],PC[22],PC[21],PC[20],PC[19],PC[18],PC[17],PC[16],PC[15],PC[14],PC[13],PC[12],PC[11],PC[10],PC[9],PC[8],PC[7],PC[6],PC[5],PC[4],PC[3],PC[2],PC[1],PC[0]
*.IPIN
*+ READ_DATA[31],READ_DATA[30],READ_DATA[29],READ_DATA[28],READ_DATA[27],READ_DATA[26],READ_DATA[25],READ_DATA[24],READ_DATA[23],READ_DATA[22],READ_DATA[21],READ_DATA[20],READ_DATA[19],READ_DATA[18],READ_DATA[17],READ_DATA[16],READ_DATA[15],READ_DATA[14],READ_DATA[13],READ_DATA[12],READ_DATA[11],READ_DATA[10],READ_DATA[9],READ_DATA[8],READ_DATA[7],READ_DATA[6],READ_DATA[5],READ_DATA[4],READ_DATA[3],READ_DATA[2],READ_DATA[1],READ_DATA[0]
*.OPIN
*+ ALU_RESULT[31],ALU_RESULT[30],ALU_RESULT[29],ALU_RESULT[28],ALU_RESULT[27],ALU_RESULT[26],ALU_RESULT[25],ALU_RESULT[24],ALU_RESULT[23],ALU_RESULT[22],ALU_RESULT[21],ALU_RESULT[20],ALU_RESULT[19],ALU_RESULT[18],ALU_RESULT[17],ALU_RESULT[16],ALU_RESULT[15],ALU_RESULT[14],ALU_RESULT[13],ALU_RESULT[12],ALU_RESULT[11],ALU_RESULT[10],ALU_RESULT[9],ALU_RESULT[8],ALU_RESULT[7],ALU_RESULT[6],ALU_RESULT[5],ALU_RESULT[4],ALU_RESULT[3],ALU_RESULT[2],ALU_RESULT[1],ALU_RESULT[0]
*.OPIN
*+ WRITE_DATA[31],WRITE_DATA[30],WRITE_DATA[29],WRITE_DATA[28],WRITE_DATA[27],WRITE_DATA[26],WRITE_DATA[25],WRITE_DATA[24],WRITE_DATA[23],WRITE_DATA[22],WRITE_DATA[21],WRITE_DATA[20],WRITE_DATA[19],WRITE_DATA[18],WRITE_DATA[17],WRITE_DATA[16],WRITE_DATA[15],WRITE_DATA[14],WRITE_DATA[13],WRITE_DATA[12],WRITE_DATA[11],WRITE_DATA[10],WRITE_DATA[9],WRITE_DATA[8],WRITE_DATA[7],WRITE_DATA[6],WRITE_DATA[5],WRITE_DATA[4],WRITE_DATA[3],WRITE_DATA[2],WRITE_DATA[1],WRITE_DATA[0]
*.IPIN MEM_WRITE
*--------BEGIN_XMIPS_INST_XDATAPATH_INST_XREGFILE_INST->REGFILE
*.IPIN CLK
*.IPIN ADDR1[4],ADDR1[3],ADDR1[2],ADDR1[1],ADDR1[0]
*.IPIN ADDR2[4],ADDR2[3],ADDR2[2],ADDR2[1],ADDR2[0]
*.OPIN
*+ DATA1[31],DATA1[30],DATA1[29],DATA1[28],DATA1[27],DATA1[26],DATA1[25],DATA1[24],DATA1[23],DATA1[22],DATA1[21],DATA1[20],DATA1[19],DATA1[18],DATA1[17],DATA1[16],DATA1[15],DATA1[14],DATA1[13],DATA1[12],DATA1[11],DATA1[10],DATA1[9],DATA1[8],DATA1[7],DATA1[6],DATA1[5],DATA1[4],DATA1[3],DATA1[2],DATA1[1],DATA1[0]
*.OPIN
*+ DATA2[31],DATA2[30],DATA2[29],DATA2[28],DATA2[27],DATA2[26],DATA2[25],DATA2[24],DATA2[23],DATA2[22],DATA2[21],DATA2[20],DATA2[19],DATA2[18],DATA2[17],DATA2[16],DATA2[15],DATA2[14],DATA2[13],DATA2[12],DATA2[11],DATA2[10],DATA2[9],DATA2[8],DATA2[7],DATA2[6],DATA2[5],DATA2[4],DATA2[3],DATA2[2],DATA2[1],DATA2[0]
*.IPIN RW
*.IPIN ADDR3[4],ADDR3[3],ADDR3[2],ADDR3[1],ADDR3[0]
*.IPIN
*+ WDATA[31],WDATA[30],WDATA[29],WDATA[28],WDATA[27],WDATA[26],WDATA[25],WDATA[24],WDATA[23],WDATA[22],WDATA[21],WDATA[20],WDATA[19],WDATA[18],WDATA[17],WDATA[16],WDATA[15],WDATA[14],WDATA[13],WDATA[12],WDATA[11],WDATA[10],WDATA[9],WDATA[8],WDATA[7],WDATA[6],WDATA[5],WDATA[4],WDATA[3],WDATA[2],WDATA[1],WDATA[0]
* NOCONN CLK
* NOCONN ADDR1[4:0]
* NOCONN ADDR2[4:0]
* NOCONN RW
* NOCONN ADDR3[4:0]
* NOCONN WDATA[31:0]
* NOCONN DATA1[31:0]
* NOCONN DATA2[31:0]
*--------END___XMIPS_INST_XDATAPATH_INST_XREGFILE_INST->REGFILE
*--------BEGIN_XMIPS_INST_XDATAPATH_INST_XALU_INST->ALU
*.IPIN
*+ A_IN[31],A_IN[30],A_IN[29],A_IN[28],A_IN[27],A_IN[26],A_IN[25],A_IN[24],A_IN[23],A_IN[22],A_IN[21],A_IN[20],A_IN[19],A_IN[18],A_IN[17],A_IN[16],A_IN[15],A_IN[14],A_IN[13],A_IN[12],A_IN[11],A_IN[10],A_IN[9],A_IN[8],A_IN[7],A_IN[6],A_IN[5],A_IN[4],A_IN[3],A_IN[2],A_IN[1],A_IN[0]
*.OPIN ZERO
*.IPIN
*+ B_IN[31],B_IN[30],B_IN[29],B_IN[28],B_IN[27],B_IN[26],B_IN[25],B_IN[24],B_IN[23],B_IN[22],B_IN[21],B_IN[20],B_IN[19],B_IN[18],B_IN[17],B_IN[16],B_IN[15],B_IN[14],B_IN[13],B_IN[12],B_IN[11],B_IN[10],B_IN[9],B_IN[8],B_IN[7],B_IN[6],B_IN[5],B_IN[4],B_IN[3],B_IN[2],B_IN[1],B_IN[0]
*.IPIN F_IN[2],F_IN[1],F_IN[0]
*.OPIN C_OUT
*.OPIN
*+ Y_OUT[31],Y_OUT[30],Y_OUT[29],Y_OUT[28],Y_OUT[27],Y_OUT[26],Y_OUT[25],Y_OUT[24],Y_OUT[23],Y_OUT[22],Y_OUT[21],Y_OUT[20],Y_OUT[19],Y_OUT[18],Y_OUT[17],Y_OUT[16],Y_OUT[15],Y_OUT[14],Y_OUT[13],Y_OUT[12],Y_OUT[11],Y_OUT[10],Y_OUT[9],Y_OUT[8],Y_OUT[7],Y_OUT[6],Y_OUT[5],Y_OUT[4],Y_OUT[3],Y_OUT[2],Y_OUT[1],Y_OUT[0]
* NOCONN ZERO
* NOCONN A_IN[31:0]
* NOCONN B_IN[31:0]
* NOCONN F_IN[2:0]
* NOCONN C_OUT
* NOCONN Y_OUT[31:0]
*--------END___XMIPS_INST_XDATAPATH_INST_XALU_INST->ALU
*--------BEGIN_XMIPS_INST_XDATAPATH_INST_XSIGN_EXTEND_INST->SIGN_EXTEND
*.OPIN
*+ ODATA[31],ODATA[30],ODATA[29],ODATA[28],ODATA[27],ODATA[26],ODATA[25],ODATA[24],ODATA[23],ODATA[22],ODATA[21],ODATA[20],ODATA[19],ODATA[18],ODATA[17],ODATA[16],ODATA[15],ODATA[14],ODATA[13],ODATA[12],ODATA[11],ODATA[10],ODATA[9],ODATA[8],ODATA[7],ODATA[6],ODATA[5],ODATA[4],ODATA[3],ODATA[2],ODATA[1],ODATA[0]
*.IPIN
*+ IDATA[15],IDATA[14],IDATA[13],IDATA[12],IDATA[11],IDATA[10],IDATA[9],IDATA[8],IDATA[7],IDATA[6],IDATA[5],IDATA[4],IDATA[3],IDATA[2],IDATA[1],IDATA[0]
* NOCONN ODATA[31:0]
* NOCONN IDATA[15:0]
*--------END___XMIPS_INST_XDATAPATH_INST_XSIGN_EXTEND_INST->SIGN_EXTEND
* NOCONN CLK
* NOCONN RST
* NOCONN ALUCONTROL[2:0]
* NOCONN ALU_SRC
* NOCONN BRANCH
* NOCONN JUMP
* NOCONN MEM_TO_REG
* NOCONN MEM_WRITE
* NOCONN REG_DST
* NOCONN REG_WRITE
* NOCONN INSTR[31:0]
* NOCONN READ_DATA[31:0]
* NOCONN PC[31:0]
* NOCONN WRITE_DATA[31:0]
* NOCONN ALU_RESULT[31:0]
* NOCONN ALU_OUT[31:0]
* NOCONN SRC_A[31:0]
* NOCONN SRC_B[31:0]
* NOCONN IMM_EXT[31:0]
* NOCONN REG_DATA1[31:0]
* NOCONN REG_DATA2[31:0]
* NOCONN RESULT[31:0]
* NOCONN C_OUT
* NOCONN ZERO
* NOCONN WRITE_REG[4:0]
*--------END___XMIPS_INST_XDATAPATH_INST->DATAPATH
* NOCONN CLK
* NOCONN RST
* NOCONN IMEM_DATA[31:0]
* NOCONN DMEM_RDATA[31:0]
* NOCONN IMEM_ADDR[31:0]
* NOCONN DMEM_WE
* NOCONN DMEM_ADDR[31:0]
* NOCONN DMEM_WDATA[31:0]
*--------END___XMIPS_INST->MIPS
*--------BEGIN_XDMEM_INST->DMEM
*.IPIN CLK
*.IPIN WE
*.IPIN
*+ ADDR[31],ADDR[30],ADDR[29],ADDR[28],ADDR[27],ADDR[26],ADDR[25],ADDR[24],ADDR[23],ADDR[22],ADDR[21],ADDR[20],ADDR[19],ADDR[18],ADDR[17],ADDR[16],ADDR[15],ADDR[14],ADDR[13],ADDR[12],ADDR[11],ADDR[10],ADDR[9],ADDR[8],ADDR[7],ADDR[6],ADDR[5],ADDR[4],ADDR[3],ADDR[2],ADDR[1],ADDR[0]
*.IPIN
*+ WDATA[31],WDATA[30],WDATA[29],WDATA[28],WDATA[27],WDATA[26],WDATA[25],WDATA[24],WDATA[23],WDATA[22],WDATA[21],WDATA[20],WDATA[19],WDATA[18],WDATA[17],WDATA[16],WDATA[15],WDATA[14],WDATA[13],WDATA[12],WDATA[11],WDATA[10],WDATA[9],WDATA[8],WDATA[7],WDATA[6],WDATA[5],WDATA[4],WDATA[3],WDATA[2],WDATA[1],WDATA[0]
*.OPIN
*+ RDATA[31],RDATA[30],RDATA[29],RDATA[28],RDATA[27],RDATA[26],RDATA[25],RDATA[24],RDATA[23],RDATA[22],RDATA[21],RDATA[20],RDATA[19],RDATA[18],RDATA[17],RDATA[16],RDATA[15],RDATA[14],RDATA[13],RDATA[12],RDATA[11],RDATA[10],RDATA[9],RDATA[8],RDATA[7],RDATA[6],RDATA[5],RDATA[4],RDATA[3],RDATA[2],RDATA[1],RDATA[0]
* NOCONN RDATA[31:0]
* NOCONN CLK
* NOCONN WE
* NOCONN ADDR[31:0]
* NOCONN WDATA[31:0]
*--------END___XDMEM_INST->DMEM
*--------BEGIN_XIMEM_INST->IMEM
*.IPIN ADDR[5],ADDR[4],ADDR[3],ADDR[2],ADDR[1],ADDR[0]
*.OPIN
*+ DATA[31],DATA[30],DATA[29],DATA[28],DATA[27],DATA[26],DATA[25],DATA[24],DATA[23],DATA[22],DATA[21],DATA[20],DATA[19],DATA[18],DATA[17],DATA[16],DATA[15],DATA[14],DATA[13],DATA[12],DATA[11],DATA[10],DATA[9],DATA[8],DATA[7],DATA[6],DATA[5],DATA[4],DATA[3],DATA[2],DATA[1],DATA[0]
* NOCONN DATA[31:0]
* NOCONN ADDR[5:0]
*--------END___XIMEM_INST->IMEM
* NOCONN IMEM_ADDR[31:0]
.end

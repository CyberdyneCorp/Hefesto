** sch_path: /pdk/sky130A/libs.tech/xschem/sky130_tests/test_lvs_ignore.sch
**.subckt test_lvs_ignore
x5 net3 net1 VCC VSS not W_N=0.5 L_N=1 W_P=1 L_P=1
V2 net1 GND 0
R1 VDD net2 100MEG
C1 net2 GND 1p
R3 VDD net1 100MEG
x1 STARTUP net2 VCC VSS not W_N=0.5 L_N=1 W_P=1 L_P=1
**.ends

* expanding   symbol:  sky130_tests/not.sym # of pins=2
** sym_path: /pdk/sky130A/libs.tech/xschem/sky130_tests/not.sym
** sch_path: /pdk/sky130A/libs.tech/xschem/sky130_tests/not.sch
.subckt not y a VCCPIN VSSPIN     W_N=1 L_N=0.15 W_P=2 L_P=0.15
*.opin y
*.ipin a
XM1 DN a VSSPIN VSSPIN sky130_fd_pr__nfet_01v8 L=L_N W=W_N nf=1 ad='int((1 + 1)/2) * W_N / 1 * 0.29' as='int((1 + 2)/2) * W_N / 1 * 0.29'
+ pd='2*int((1 + 1)/2) * (W_N / 1 + 0.29)' ps='2*int((1 + 2)/2) * (W_N / 1 + 0.29)' nrd='0.29 / W_N ' nrs='0.29 / W_N ' sa=0 sb=0 sd=0
+ mult=1
XM2 DP a VCCPIN VCCPIN sky130_fd_pr__pfet_01v8 L=L_P W=W_P nf=1 ad='int((1 + 1)/2) * W_P / 1 * 0.29' as='int((1 + 2)/2) * W_P / 1 * 0.29'
+ pd='2*int((1 + 1)/2) * (W_P / 1 + 0.29)' ps='2*int((1 + 2)/2) * (W_P / 1 + 0.29)' nrd='0.29 / W_P ' nrs='0.29 / W_P ' sa=0 sb=0 sd=0
+ mult=1
Vmeas DP y 0
.save i(vmeas)
Vmeas1 y DN 0
.save i(vmeas1)
.save v(dp)
.save v(dn)
.ends

.GLOBAL GND
.GLOBAL VDD
.end

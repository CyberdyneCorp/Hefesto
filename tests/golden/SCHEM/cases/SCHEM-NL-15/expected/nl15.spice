** sch_path: /work/input/nl15.sch
**.subckt nl15
x1 A B amp
x2 A B amp_fast
**.ends

* expanding   symbol:  amp.sym # of pins=2
** sym_path: /work/input/amp.sym
** sch_path: /work/input/amp.sch
.subckt amp IN OUT
*.iopin IN
*.iopin OUT
R1 IN OUT 1k
.ends

* expanding   symbol:  amp_fast.sym # of pins=2
** sym_path: /work/input/amp.sym
** sch_path: /work/input/amp_fast.sch
.subckt amp_fast IN OUT
*.iopin IN
*.iopin OUT
R1 IN OUT 100
.ends

.end

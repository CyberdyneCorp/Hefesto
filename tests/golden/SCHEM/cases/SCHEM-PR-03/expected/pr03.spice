** sch_path: /work/input/pr03.sch
**.subckt pr03
x1 N2 N3 N1 pinsort
x2 N1 N2 pinpart
**.ends

* expanding   symbol:  pinsort.sym # of pins=3
** sym_path: /work/input/pinsort.sym
** sch_path: /work/input/pinsort.sch
.subckt pinsort A C B
*.iopin A
*.iopin B
*.iopin C
R1 A B 1k
R2 B C 1k
.ends

* expanding   symbol:  pinpart.sym # of pins=2
** sym_path: /work/input/pinpart.sym
** sch_path: /work/input/pinpart.sch
.subckt pinpart B A
*.iopin A
*.iopin B
R1 A B 1k
.ends

.end

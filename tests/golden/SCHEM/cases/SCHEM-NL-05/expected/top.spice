** sch_path: /pdk/sky130A/libs.tech/xschem/sky130_tests/top.sch
**.subckt top
x1 test_nmos
x2 test_pmos
x5 test_inv
x3 test_res
x4 test_bipolar
x6 test_diode
XD1 net1 net2 sky130_fd_pr__diode_pw2nd_05v5 area=1e12 perim=4e6
XD2 net3 net4 sky130_fd_pr__diode_pw2nd_11v0 area=1e12 perim=4e6
XQ1 net5 net6 net7 sky130_fd_pr__pnp_05v5_W0p68L0p68 m=1 mult=1
XR1 net8 net9 net10 sky130_fd_pr__res_iso_pw W=2.65 L=2.65
XR2 net11 net12 net13 sky130_fd_pr__res_generic_nd W=1 L=1 mult=1
XR3 net14 net15 net16 sky130_fd_pr__res_generic_pd W=1 L=1 mult=1
XR4 net17 net18 sky130_fd_pr__res_generic_po W=1 L=1
XR5 net19 net20 net21 sky130_fd_pr__res_high_po W=1 L=1 mult=1
XR6 net22 net23 net24 sky130_fd_pr__res_high_po_0p35 L=0.35 mult=1
XR7 net25 net26 net27 sky130_fd_pr__res_high_po_0p69 L=0.69 mult=1
XR8 net28 net29 net30 sky130_fd_pr__res_high_po_1p41 L=1.41 mult=1
XR9 net31 net32 net33 sky130_fd_pr__res_xhigh_po W=1 L=1 mult=1
XR10 net34 net35 net36 sky130_fd_pr__res_xhigh_po_0p35 L=0.35 mult=1
XR11 net37 net38 net39 sky130_fd_pr__res_xhigh_po_0p69 L=0.69 mult=1
XR12 net40 net41 net42 sky130_fd_pr__res_xhigh_po_1p41 L=1.41 mult=1
XM1 net43 net44 net45 net46 sky130_fd_pr__nfet_01v8_lvt L=0.15 W=1 nf=1 ad=0.29 as=0.29 pd=2.58 ps=2.58 nrd=0.29 nrs=0.29 sa=0
+ sb=0 sd=0 mult=1
XM2 net47 net48 net49 net50 sky130_fd_pr__nfet_01v8 L=0.15 W=1 nf=1 ad=0.29 as=0.29 pd=2.58 ps=2.58 nrd=0.29 nrs=0.29 sa=0 sb=0
+ sd=0 mult=1
XM3 net51 net52 net53 net54 sky130_fd_pr__nfet_03v3_nvt L=0.5 W=1 nf=1 ad=0.29 as=0.29 pd=2.58 ps=2.58 nrd=0.29 nrs=0.29 sa=0 sb=0
+ sd=0 mult=1
XM4 net55 net56 net57 net58 sky130_fd_pr__nfet_05v0_nvt L=0.9 W=1 nf=1 ad=0.29 as=0.29 pd=2.58 ps=2.58 nrd=0.29 nrs=0.29 sa=0 sb=0
+ sd=0 mult=1
XM5 net59 net60 net61 net62 sky130_fd_pr__nfet_g5v0d10v5 L=0.5 W=1 nf=1 ad=0.29 as=0.29 pd=2.58 ps=2.58 nrd=0.29 nrs=0.29 sa=0
+ sb=0 sd=0 mult=1
XM6 net63 net64 net65 net66 sky130_fd_pr__nfet_g5v0d16v0 L=0.7 W=5.0 nf=1 ad=1.45 as=1.45 pd=10.58 ps=10.58 nrd=0.058 nrs=0.058
+ sa=0 sb=0 sd=0 mult=1
XM8 net67 net68 net69 net70 sky130_fd_pr__pfet_01v8_hvt L=0.15 W=1 nf=1 ad=0.29 as=0.29 pd=2.58 ps=2.58 nrd=0.29 nrs=0.29 sa=0
+ sb=0 sd=0 mult=1
XM9 net71 net72 net73 net74 sky130_fd_pr__pfet_g5v0d10v5 L=0.5 W=1 nf=1 ad=0.29 as=0.29 pd=2.58 ps=2.58 nrd=0.29 nrs=0.29 sa=0
+ sb=0 sd=0 mult=1
XM10 net75 net76 net77 net78 sky130_fd_pr__pfet_01v8_lvt L=0.35 W=1 nf=1 ad=0.29 as=0.29 pd=2.58 ps=2.58 nrd=0.29 nrs=0.29 sa=0
+ sb=0 sd=0 mult=1
XM11 net79 net80 net81 net82 sky130_fd_pr__pfet_01v8 L=0.15 W=1 nf=1 ad=0.29 as=0.29 pd=2.58 ps=2.58 nrd=0.29 nrs=0.29 sa=0 sb=0
+ sd=0 mult=1
XM12 net83 net84 net85 net86 sky130_fd_pr__pfet_g5v0d16v0 L=0.66 W=5.0 nf=1 ad=1.45 as=1.45 pd=10.58 ps=10.58 nrd=0.058 nrs=0.058
+ sa=0 sb=0 sd=0 mult=1
x7 test_comparator
XM13 net87 net88 net89 net90 sky130_fd_pr__pfet_20v0 L=0.5 W=60
x8 gates
XC1 net91 net92 sky130_fd_pr__cap_mim_m3_1 W=1 L=1 MF=1
XC2 net93 net94 sky130_fd_pr__cap_mim_m3_2 W=1 L=1 MF=1
x9 test_format_override
x11 test_nmos_sizes
x10 gates_sky130
x12 test_stdcells
x13 all_sky130_gates
XC3 net95 net96 net97 sky130_fd_pr__cap_var_lvt W=0.5 L=0.5 VM=1
XC4 net98 net99 net100 sky130_fd_pr__cap_var_hvt W=0.5 L=0.5 VM=1
x14 test_varactor
x15 test_vpp_cap
XC5 net101 net102 net103 sky130_fd_pr__cap_vpp_11p5x11p7_l1m1m2m3m4_shieldm5 mult=1
x16 tb
XM17 net104 net105 net106 GND sky130_fd_pr__nfet_01v8_lvt L=0.15 W=1 nf=1 ad=0.29 as=0.29 pd=2.58 ps=2.58 nrd=0.29 nrs=0.29 sa=0
+ sb=0 sd=0 mult=1
XM18 net107 net108 net109 GND sky130_fd_pr__nfet_01v8 L=0.15 W=1 nf=1 ad=0.29 as=0.29 pd=2.58 ps=2.58 nrd=0.29 nrs=0.29 sa=0 sb=0
+ sd=0 mult=1
XM19 net110 net111 net112 GND sky130_fd_pr__nfet_03v3_nvt L=0.5 W=1 nf=1 ad=0.29 as=0.29 pd=2.58 ps=2.58 nrd=0.29 nrs=0.29 sa=0
+ sb=0 sd=0 mult=1
XM20 net113 net114 net115 GND sky130_fd_pr__nfet_05v0_nvt L=0.9 W=1 nf=1 ad=0.29 as=0.29 pd=2.58 ps=2.58 nrd=0.29 nrs=0.29 sa=0
+ sb=0 sd=0 mult=1
XM21 net116 net117 net118 GND sky130_fd_pr__nfet_g5v0d10v5 L=0.5 W=1 nf=1 ad=0.29 as=0.29 pd=2.58 ps=2.58 nrd=0.29 nrs=0.29 sa=0
+ sb=0 sd=0 mult=1
XM22 net119 net120 net121 GND sky130_fd_pr__nfet_g5v0d16v0 L=0.7 W=5.0 nf=1 ad=1.45 as=1.45 pd=10.58 ps=10.58 nrd=0.058 nrs=0.058
+ sa=0 sb=0 sd=0 mult=1
XM24 net122 net123 net124 VDD sky130_fd_pr__pfet_01v8_hvt L=0.15 W=1 nf=1 ad=0.29 as=0.29 pd=2.58 ps=2.58 nrd=0.29 nrs=0.29 sa=0
+ sb=0 sd=0 mult=1
XM25 net125 net126 net127 VDD sky130_fd_pr__pfet_g5v0d10v5 L=0.5 W=1 nf=1 ad=0.29 as=0.29 pd=2.58 ps=2.58 nrd=0.29 nrs=0.29 sa=0
+ sb=0 sd=0 mult=1
XM26 net128 net129 net130 VDD sky130_fd_pr__pfet_01v8_lvt L=0.35 W=1 nf=1 ad=0.29 as=0.29 pd=2.58 ps=2.58 nrd=0.29 nrs=0.29 sa=0
+ sb=0 sd=0 mult=1
XM27 net131 net132 net133 VDD sky130_fd_pr__pfet_01v8 L=0.15 W=1 nf=1 ad=0.29 as=0.29 pd=2.58 ps=2.58 nrd=0.29 nrs=0.29 sa=0 sb=0
+ sd=0 mult=1
XM28 net134 net135 net136 VDD sky130_fd_pr__pfet_g5v0d16v0 L=0.66 W=5.0 nf=1 ad=1.45 as=1.45 pd=10.58 ps=10.58 nrd=0.058 nrs=0.058
+ sa=0 sb=0 sd=0 mult=1
XM29 net137 net138 net139 VDD sky130_fd_pr__pfet_20v0 L=0.5 W=60
x18 test_mim_cap
x19 LACG
x20 test_ff
x21 test_analog
x22 simulate_ff
XM7 net140 net141 net142 net143 sky130_fd_pr__nfet_20v0 L=0.5 W=40
XM23 net144 net145 net146 GND sky130_fd_pr__nfet_20v0 L=0.5 W=40
XM14 net147 net148 net149 net150 net151 sky130_fd_pr__nfet_20v0_iso W=40 L=0.5
XM15 net152 net153 net154 net155 sky130_fd_pr__nfet_20v0_nvt W=40 L=0.5
XM16 net156 net157 net158 net159 sky130_fd_pr__nfet_20v0_zvt W=60 L=0.5
x23 tb_ft_test
x24 tb_ft_test_2
x25 tb_bandgap
R13 net160 net161 sky130_fd_pr__res_generic_m1 W=1 L=1
XR14 net162 net163 net164 sky130_fd_pr__res_high_po_2p85 L=2.85 mult=1
XR15 net165 net166 net167 sky130_fd_pr__res_high_po_5p73 L=5.73 mult=1
XR16 net168 net169 net170 sky130_fd_pr__res_xhigh_po_2p85 L=2.85 mult=1
XR17 net171 net172 net173 sky130_fd_pr__res_xhigh_po_5p73 L=5.73 mult=1
x26 logic_ngspice
XM30 net174 net175 net176 net177 sky130_fd_pr__esd_nfet_01v8 L=0.165 W=20.35 nf=1 ad=5.9015 as=5.9015 pd=41.28 ps=41.28
+ nrd=0.0142506142506142 nrs=0.0142506142506142 sa=0 sb=0 sd=0 mult=1
XM31 net178 net179 net180 net181 sky130_fd_pr__esd_nfet_g5v0d10v5 L=0.55 W=21.5 nf=1 ad=6.235 as=6.235 pd=43.58 ps=43.58
+ nrd=0.0134883720930233 nrs=0.0134883720930233 sa=0 sb=0 sd=0 mult=1
XM32 net182 net183 net184 net185 sky130_fd_pr__esd_nfet_g5v0d10v5_nvt L=0.55 W=21.5 nf=1 ad=6.235 as=6.235 pd=43.58 ps=43.58
+ nrd=0.0134883720930233 nrs=0.0134883720930233 sa=0 sb=0 sd=0 mult=1
XM33 net186 net187 net188 net189 sky130_fd_pr__nfet_01v8_lvt L=0.15 W='1 * 1 ' nf=1 ad=0.29 as=0.29 pd=2.58 ps=2.58 nrd=0.29 nrs=0.29
+ sa=0 sb=0 sd=0 mult=1
XM34 net190 net191 net192 net193 sky130_fd_pr__nfet_01v8 L=0.15 W='1 * 1 ' nf=1 ad=0.29 as=0.29 pd=2.58 ps=2.58 nrd=0.29 nrs=0.29 sa=0
+ sb=0 sd=0 mult=1
XM35 net194 net195 net196 net197 sky130_fd_pr__nfet_03v3_nvt L=0.5 W='1 * 1 ' nf=1 ad=0.29 as=0.29 pd=2.58 ps=2.58 nrd=0.29 nrs=0.29
+ sa=0 sb=0 sd=0 mult=1
XM36 net198 net199 net200 net201 sky130_fd_pr__nfet_05v0_nvt L=0.9 W='1 * 1 ' nf=1 ad=0.29 as=0.29 pd=2.58 ps=2.58 nrd=0.29 nrs=0.29
+ sa=0 sb=0 sd=0 mult=1
XM37 net202 net203 net204 net205 sky130_fd_pr__nfet_g5v0d10v5 L=0.5 W='1 * 1 ' nf=1 ad=0.29 as=0.29 pd=2.58 ps=2.58 nrd=0.29 nrs=0.29
+ sa=0 sb=0 sd=0 mult=1
XM38 net206 net207 net208 net209 sky130_fd_pr__nfet_g5v0d16v0 L=0.7 W='5.0 * 1 ' nf=1 ad=1.45 as=1.45 pd=10.58 ps=10.58 nrd=0.058 nrs=0.058
+ sa=0 sb=0 sd=0 mult=1
XM39 net210 net211 net212 net213 sky130_fd_pr__pfet_01v8_hvt L=0.15 W='1 * 1 ' nf=1 ad=0.29 as=0.29 pd=2.58 ps=2.58 nrd=0.29 nrs=0.29
+ sa=0 sb=0 sd=0 mult=1
XM40 net214 net215 net216 net217 sky130_fd_pr__pfet_g5v0d10v5 L=0.5 W='1 * 1 ' nf=1 ad=0.29 as=0.29 pd=2.58 ps=2.58 nrd=0.29 nrs=0.29
+ sa=0 sb=0 sd=0 mult=1
XM41 net218 net219 net220 net221 sky130_fd_pr__pfet_01v8_lvt L=0.35 W='1 * 2 ' nf=2 ad=0.145 as=0.29 pd=1.58 ps=3.16 nrd=0.29 nrs=0.29
+ sa=0 sb=0 sd=0 mult=1
XM42 net222 net223 net224 net225 sky130_fd_pr__pfet_01v8 L=0.15 W='1 * 1 ' nf=1 ad=0.29 as=0.29 pd=2.58 ps=2.58 nrd=0.29 nrs=0.29 sa=0
+ sb=0 sd=0 mult=1
XM43 net226 net227 net228 net229 sky130_fd_pr__pfet_g5v0d16v0 L=0.66 W='5.0 * 1 ' nf=1 ad=1.45 as=1.45 pd=10.58 ps=10.58 nrd=0.058
+ nrs=0.058 sa=0 sb=0 sd=0 mult=1
x28 test_carry_lookahead
XQ2 net230 net231 net232 net233 sky130_fd_pr__npn_05v5_w1p00l2p00 m=1 mult=1
x29 test_nand2_noschematic
R18 net234 net235 sky130_fd_pr__res_generic_m2 W=1 L=1
R19 net236 net237 sky130_fd_pr__res_generic_m3 W=1 L=1
R20 net238 net239 sky130_fd_pr__res_generic_m4 W=1 L=1
R21 net240 net241 sky130_fd_pr__res_generic_l1 W=1 L=1
x30 test_s_xfer
x31 test_multisim
x32 test_ac
x33 test_mos_binning
R22 net242 net243 sky130_fd_pr__res_generic_m5 W=1 L=1
x34 test_sweep_mos_w
x17 tb_bandgap_opamp
x35 tb_charge_pump
x36 cmos_ac_sweep
x37 test_hvl_cells
x40 test_short_option
x41 test_lvs_ignore
x38 test_generators
x39 optimize_delay
x42 test_customplot
x43 intuitive_interface_cheatsheet
x44 sky130_oscillator
XD3 net244 net245 sky130_fd_pr__photodiode area=1e12 perim=4e6
x45 sky130_mismatch
x46 test_sweep_res_l
x47 tb_diff_amp
x48 montecarlo_mismatch_sim
**** begin user architecture code

** opencircuitdesign pdks install
.lib /pdk/sky130A/libs.tech/combined/sky130.lib.spice tt

.lib /pdk/sky130A/libs.tech/combined/sky130.lib.spice tt
**** end user architecture code
**.ends

* expanding   symbol:  sky130_tests/test_nmos.sym # of pins=0
** sym_path: /pdk/sky130A/libs.tech/xschem/sky130_tests/test_nmos.sym
** sch_path: /pdk/sky130A/libs.tech/xschem/sky130_tests/test_nmos.sch
.subckt test_nmos
*.ipin G1v8
*.ipin D1v8
*.ipin B
Vd1 D1v8 net1 0
.save i(vd1)
Vd3 D3v3 net2 0
.save i(vd3)
Vd2 D1v8 net3 0
.save i(vd2)
Vd4 D5v0 net4 0
.save i(vd4)
E1 D5v0 0 D1v8 0 '5/1.8'
E2 D3v3 0 D1v8 0 '3.3/1.8'
E3 G5v0 0 G1v8 0 '5/1.8'
E4 G3v3 0 G1v8 0 '3.3/1.8'
Vd5 D10v5 net5 0
.save i(vd5)
E5 D10v5 0 D1v8 0 '10.5/1.8'
E6 D16v0 0 D1v8 0 '16.0/1.8'
Vd6 D16v0 net6 0
.save i(vd6)
Vd7 D1v8 net7 0
.save i(vd7)
E7 D20v0 0 D1v8 0 '20.0/1.8'
XM1 net1 G1v8 S B sky130_fd_pr__nfet_01v8_lvt L=0.15 W=1 nf=1 ad=0.29 as=0.29 pd=2.58 ps=2.58 nrd=0.29 nrs=0.29 sa=0 sb=0 sd=0
+ mult=1
XM2 net3 G1v8 S B sky130_fd_pr__nfet_01v8 L=0.15 W=1 nf=1 ad=0.29 as=0.29 pd=2.58 ps=2.58 nrd=0.29 nrs=0.29 sa=0 sb=0 sd=0 mult=1
XM3 net2 G3v3 S B sky130_fd_pr__nfet_03v3_nvt L=0.5 W=1 nf=1 ad=0.29 as=0.29 pd=2.58 ps=2.58 nrd=0.29 nrs=0.29 sa=0 sb=0 sd=0
+ mult=1
XM4 net4 G5v0 S B sky130_fd_pr__nfet_05v0_nvt L=0.9 W=1 nf=1 ad=0.29 as=0.29 pd=2.58 ps=2.58 nrd=0.29 nrs=0.29 sa=0 sb=0 sd=0
+ mult=1
XM5 net5 G5v0 S B sky130_fd_pr__nfet_g5v0d10v5 L=0.5 W=1 nf=1 ad=0.29 as=0.29 pd=2.58 ps=2.58 nrd=0.29 nrs=0.29 sa=0 sb=0 sd=0
+ mult=1
XM6 net6 G5v0 S B sky130_fd_pr__nfet_g5v0d16v0 L=0.7 W=5.0 nf=1 ad=1.45 as=1.45 pd=10.58 ps=10.58 nrd=0.058 nrs=0.058 sa=0 sb=0
+ sd=0 mult=1
Vd8 D1v8 net8 0
.save i(vd8)
XM7 net7 G1v8 S B sky130_fd_pr__nfet_20v0 L=0.5 W=40
XM8 net8 G1v8 S B sky130_fd_pr__nfet_20v0_zvt W=60 L=0.5
Vd9 D1v8 net9 0
.save i(vd9)
XM9 net9 G1v8 S B sky130_fd_pr__nfet_01v8_lvt L=0.15 W='0.5 * 2 ' nf=2 ad=0.0725 as=0.145 pd=1.08 ps=2.16 nrd=0.58 nrs=0.58 sa=0 sb=0
+ sd=0 mult=1
Vd10 D1v8 net10 0
.save i(vd10)
Vd11 D1v8 net12 0
.save i(vd11)
Vd12 D3v3 net11 0
.save i(vd12)
Vd13 D5v0 net13 0
.save i(vd13)
Vd14 D10v5 net14 0
.save i(vd14)
Vd15 D16v0 net15 0
.save i(vd15)
Vd16 D1v8 net16 0
.save i(vd16)
XM10 net10 G1v8 S B sky130_fd_pr__nfet_01v8_lvt L=0.15 W=1 nf=1 ad=0.29 as=0.29 pd=2.58 ps=2.58 nrd=0.29 nrs=0.29 sa=0 sb=0 sd=0
+ mult=1
XM11 net12 G1v8 S B sky130_fd_pr__nfet_01v8 L=0.15 W=1 nf=1 ad=0.29 as=0.29 pd=2.58 ps=2.58 nrd=0.29 nrs=0.29 sa=0 sb=0 sd=0
+ mult=1
XM12 net11 G3v3 S B sky130_fd_pr__nfet_03v3_nvt L=0.5 W=1 nf=1 ad=0.29 as=0.29 pd=2.58 ps=2.58 nrd=0.29 nrs=0.29 sa=0 sb=0 sd=0
+ mult=1
XM13 net13 G5v0 S B sky130_fd_pr__nfet_05v0_nvt L=0.9 W=1 nf=1 ad=0.29 as=0.29 pd=2.58 ps=2.58 nrd=0.29 nrs=0.29 sa=0 sb=0 sd=0
+ mult=1
XM14 net14 G5v0 S B sky130_fd_pr__nfet_g5v0d10v5 L=0.5 W=1 nf=1 ad=0.29 as=0.29 pd=2.58 ps=2.58 nrd=0.29 nrs=0.29 sa=0 sb=0 sd=0
+ mult=1
XM15 net15 G5v0 S B sky130_fd_pr__nfet_g5v0d16v0 L=0.7 W=5.0 nf=1 ad=1.45 as=1.45 pd=10.58 ps=10.58 nrd=0.058 nrs=0.058 sa=0 sb=0
+ sd=0 mult=1
XM16 net16 G1v8 S B sky130_fd_pr__nfet_20v0 L=0.5 W=40
XM32 net17 G5v0 S B sky130_fd_pr__esd_nfet_05v0_nvt L=2 W=10 nf=1 ad=2.9 as=2.9 pd=20.58 ps=20.58 nrd=0.029 nrs=0.029 sa=0 sb=0
+ sd=0 mult=1
Vd17 D5v0 net17 0
.save i(vd17)
.ends

* expanding   symbol:  sky130_tests/test_pmos.sym # of pins=0
** sym_path: /pdk/sky130A/libs.tech/xschem/sky130_tests/test_pmos.sym
** sch_path: /pdk/sky130A/libs.tech/xschem/sky130_tests/test_pmos.sch
.subckt test_pmos
*.ipin G1v8
*.ipin D1v8
*.ipin B
Vd1 net1 D1v8 0
.save i(vd1)
Vd2 net2 D1v8 0
.save i(vd2)
E1 D5v0 0 D1v8 0 '5/1.8'
E2 D3v3 0 D1v8 0 '3.3/1.8'
E3 G5v0 0 G1v8 0 '5/1.8'
E4 G3v3 0 G1v8 0 '3.3/1.8'
E5 D10v5 0 D1v8 0 '10.5/1.8'
Vd3 net3 D1v8 0
.save i(vd3)
XM3 net3 G1v8 S B sky130_fd_pr__pfet_01v8_hvt L=0.15 W=1 nf=1 ad=0.29 as=0.29 pd=2.58 ps=2.58 nrd=0.29 nrs=0.29 sa=0 sb=0 sd=0
+ mult=1
Vd4 net4 D10v5 0
.save i(vd4)
XM4 net4 G5v0 S B sky130_fd_pr__pfet_g5v0d10v5 L=0.5 W=1 nf=1 ad=0.29 as=0.29 pd=2.58 ps=2.58 nrd=0.29 nrs=0.29 sa=0 sb=0 sd=0
+ mult=1
XM1 net1 G1v8 S B sky130_fd_pr__pfet_01v8_lvt L=0.35 W=1 nf=1 ad=0.29 as=0.29 pd=2.58 ps=2.58 nrd=0.29 nrs=0.29 sa=0 sb=0 sd=0
+ mult=1
XM2 net2 G1v8 S B sky130_fd_pr__pfet_01v8 L=0.15 W=1 nf=1 ad=0.29 as=0.29 pd=2.58 ps=2.58 nrd=0.29 nrs=0.29 sa=0 sb=0 sd=0 mult=1
Vd5 net5 D16v0 0
.save i(vd5)
XM5 net5 G5v0 S B sky130_fd_pr__pfet_g5v0d16v0 L=0.66 W=5.0 nf=1 ad=1.45 as=1.45 pd=10.58 ps=10.58 nrd=0.058 nrs=0.058 sa=0 sb=0
+ sd=0 mult=1
E6 D16v0 0 D1v8 0 '16.0/1.8'
E7 D20v0 0 D1v8 0 '20.0/1.8'
XM6 net6 G5v0 S B sky130_fd_pr__pfet_20v0 L=0.5 W=60
Vd6 net6 D20v0 0
.save i(vd6)
Vd7 net7 D1v8 0
.save i(vd7)
Vd8 net8 D1v8 0
.save i(vd8)
Vd9 net9 D1v8 0
.save i(vd9)
XM9 net9 G1v8 S B sky130_fd_pr__pfet_01v8_hvt L=0.15 W=1 nf=1 ad=0.29 as=0.29 pd=2.58 ps=2.58 nrd=0.29 nrs=0.29 sa=0 sb=0 sd=0
+ mult=1
Vd10 net10 D10v5 0
.save i(vd10)
XM10 net10 G5v0 S B sky130_fd_pr__pfet_g5v0d10v5 L=0.5 W=1 nf=1 ad=0.29 as=0.29 pd=2.58 ps=2.58 nrd=0.29 nrs=0.29 sa=0 sb=0 sd=0
+ mult=1
XM7 net7 G1v8 S B sky130_fd_pr__pfet_01v8_lvt L=0.35 W=1 nf=1 ad=0.29 as=0.29 pd=2.58 ps=2.58 nrd=0.29 nrs=0.29 sa=0 sb=0 sd=0
+ mult=1
XM8 net8 G1v8 S B sky130_fd_pr__pfet_01v8 L=0.15 W=1 nf=1 ad=0.29 as=0.29 pd=2.58 ps=2.58 nrd=0.29 nrs=0.29 sa=0 sb=0 sd=0 mult=1
Vd11 net11 D16v0 0
.save i(vd11)
XM11 net11 G5v0 S B sky130_fd_pr__pfet_g5v0d16v0 L=0.66 W=5.0 nf=1 ad=1.45 as=1.45 pd=10.58 ps=10.58 nrd=0.058 nrs=0.058 sa=0 sb=0
+ sd=0 mult=1
XM12 net12 G5v0 S B sky130_fd_pr__pfet_20v0 L=0.5 W=60
Vd12 net12 D20v0 0
.save i(vd12)
.ends

* expanding   symbol:  sky130_tests/test_inv.sym # of pins=0
** sym_path: /pdk/sky130A/libs.tech/xschem/sky130_tests/test_inv.sym
** sch_path: /pdk/sky130A/libs.tech/xschem/sky130_tests/test_inv.sch
.subckt test_inv
C1 Z[1] 0 4f
C2 Z[2] 0 4f
C3 Z[3] 0 4f
C4 Z[4] 0 4f
C5 Z[5] 0 4f
C6 Z[6] 0 4f
C7 Z[0] 0 4.01f
C8 Y[1] 0 4f
C9 Y[2] 0 4f
C10 Y[3] 0 4f
C11 Y[4] 0 4f
C12 Y[5] 0 4f
C13 Y[6] 0 4f
C14 Y[0] 0 4.01f
x4 Z[1] Z[0] VCC VSS not W_N=WN L_N=0.15 W_P=WP L_P=0.15
x1 Z[2] Z[1] VCC VSS not W_N=WN L_N=0.15 W_P=WP L_P=0.15
x2 Z[3] Z[2] VCC VSS not W_N=WN L_N=0.15 W_P=WP L_P=0.15
x3 Z[4] Z[3] VCC VSS not W_N=WN L_N=0.15 W_P=WP L_P=0.15
x5 Z[5] Z[4] VCC VSS not W_N=WN L_N=0.15 W_P=WP L_P=0.15
x6 Z[6] Z[5] VCC VSS not W_N=WN L_N=0.15 W_P=WP L_P=0.15
x7 Z[0] Z[6] VCC VSS not W_N=WN L_N=0.15 W_P=WP L_P=0.15
x8 Y[0] Y[1] VCC VSS lvtnot W_N=WN L_N=0.15 W_P=WP L_P=0.35
x9 Y[1] Y[2] VCC VSS lvtnot W_N=WN L_N=0.15 W_P=WP L_P=0.35
x10 Y[2] Y[3] VCC VSS lvtnot W_N=WN L_N=0.15 W_P=WP L_P=0.35
x11 Y[3] Y[4] VCC VSS lvtnot W_N=WN L_N=0.15 W_P=WP L_P=0.35
x12 Y[4] Y[5] VCC VSS lvtnot W_N=WN L_N=0.15 W_P=WP L_P=0.35
x13 Y[5] Y[6] VCC VSS lvtnot W_N=WN L_N=0.15 W_P=WP L_P=0.35
x14 Y[6] Y[0] VCC VSS lvtnot W_N=WN L_N=0.15 W_P=WP L_P=0.35
**** begin user architecture code

.param VCC=1.8 WN=1 WP=2
vvss vss 0 dc 0
vvcc vcc 0
+ pwl 0 0 10n 0 10.1n 'VCC' 20n 'VCC' 20.1n 0
* .measure tran trise
* + TRIG v(z[6]) TD=10.5n VAL=0.1 RISE=1
* + TARG v(z[6]) TD=10.5n VAL=1.7 RISE=1
**** interactive sim
.control
  save all
  tran 0.004n 30n
  write test_inv.raw
  set appendwrite
  alterparam VCC=1.6
  reset
  save all
  tran 0.02n 30n
  write test_inv.raw
  quit 0
.endc

**** end user architecture code
**** begin user architecture code

**** end user architecture code
* tap: Z[6:0] --> Z[0]
* tap: Z[6:0] --> Z[1]
* tap: Z[6:0] --> Z[2]
* tap: Z[6:0] --> Z[3]
* tap: Z[6:0] --> Z[4]
* tap: Z[6:0] --> Z[5]
* tap: Z[6:0] --> Z[6]
* tap: Y[6:0] --> Y[0]
* tap: Y[6:0] --> Y[1]
* tap: Y[6:0] --> Y[2]
* tap: Y[6:0] --> Y[3]
* tap: Y[6:0] --> Y[4]
* tap: Y[6:0] --> Y[5]
* tap: Y[6:0] --> Y[6]
.ends

* expanding   symbol:  sky130_tests/test_res.sym # of pins=0
** sym_path: /pdk/sky130A/libs.tech/xschem/sky130_tests/test_res.sym
** sch_path: /pdk/sky130A/libs.tech/xschem/sky130_tests/test_res.sch
.subckt test_res
*.ipin P
*.ipin M
*.ipin B
XR1 M net1 B sky130_fd_pr__res_iso_pw W=2.65 L=2.65
Vr1 P net1 0
.save i(vr1)
Vr2 P net2 0
.save i(vr2)
XR2 M net2 B sky130_fd_pr__res_generic_nd W=1 L=1 mult=1
Vr3 P net3 0
.save i(vr3)
XR3 M net3 B sky130_fd_pr__res_generic_pd W=1 L=1 mult=1
Vr4 P net4 0
.save i(vr4)
XR4 M net4 sky130_fd_pr__res_generic_po W=1 L=1
Vr5 P net5 0
.save i(vr5)
XR5 M net5 B sky130_fd_pr__res_high_po W=1 L=1 mult=1
Vr6 P net6 0
.save i(vr6)
XR6 M net6 B sky130_fd_pr__res_high_po_0p35 L=0.35 mult=1
Vr7 P net7 0
.save i(vr7)
XR7 M net7 B sky130_fd_pr__res_high_po_0p69 L=0.69 mult=1
Vr8 P net8 0
.save i(vr8)
XR8 M net8 B sky130_fd_pr__res_high_po_1p41 L=1.41 mult=1
Vr9 P net9 0
.save i(vr9)
XR9 M net9 B sky130_fd_pr__res_xhigh_po W=1 L=1 mult=1
Vr10 P net10 0
.save i(vr10)
XR10 M net10 B sky130_fd_pr__res_xhigh_po_0p35 L=0.35 mult=1
Vr11 P net11 0
.save i(vr11)
XR11 M net11 B sky130_fd_pr__res_xhigh_po_0p69 L=0.69 mult=1
Vr12 P net12 0
.save i(vr12)
XR12 M net12 B sky130_fd_pr__res_xhigh_po_1p41 L=1.41 mult=1
Vr14 P net13 0
.save i(vr14)
R14 M net13 sky130_fd_pr__res_generic_m1 W=1 L=1
Vr13 P net14 0
.save i(vr13)
XR13 M net14 B sky130_fd_pr__res_xhigh_po_2p85 L=2.85 mult=1
Vr15 P net15 0
.save i(vr15)
XR15 M net15 B sky130_fd_pr__res_high_po_2p85 L=2.85 mult=1
Vr16 P net16 0
.save i(vr16)
Vr17 P net17 0
.save i(vr17)
XR16 M net16 B sky130_fd_pr__res_xhigh_po_5p73 L=5.73 mult=1
XR17 M net17 B sky130_fd_pr__res_high_po_5p73 L=5.73 mult=1
Vr18 P net18 0
.save i(vr18)
R18 M net18 sky130_fd_pr__res_generic_m2 W=1 L=1
Vr19 P net19 0
.save i(vr19)
R19 M net19 sky130_fd_pr__res_generic_l1 W=1 L=1
Vr20 P net20 0
.save i(vr20)
Vr21 P net21 0
.save i(vr21)
Vr22 P net22 0
.save i(vr22)
R21 M net21 sky130_fd_pr__res_generic_m4 W=1 L=1
R20 M net20 sky130_fd_pr__res_generic_m3 W=1 L=1
R22 M net22 sky130_fd_pr__res_generic_m5 W=1 L=1
Vr23 P net23 0
.save i(vr23)
XR23 M net23 B sky130_fd_pr__res_high_po W=1 L=10 mult=1
Vr24 P net24 0
.save i(vr24)
XR24 M net24 B sky130_fd_pr__res_high_po_0p35 L=3.5 mult=1
Vr25 P net25 0
.save i(vr25)
XR25 M net25 B sky130_fd_pr__res_high_po_0p69 L=6.9 mult=1
Vr26 P net26 0
.save i(vr26)
XR26 M net26 B sky130_fd_pr__res_high_po_1p41 L=14.1 mult=1
Vr27 P net27 0
.save i(vr27)
XR27 M net27 B sky130_fd_pr__res_high_po_2p85 L=28.5 mult=1
Vr28 P net28 0
.save i(vr28)
XR28 M net28 B sky130_fd_pr__res_high_po_5p73 L=57.3 mult=1
.ends

* expanding   symbol:  sky130_tests/test_bipolar.sym # of pins=0
** sym_path: /pdk/sky130A/libs.tech/xschem/sky130_tests/test_bipolar.sym
** sch_path: /pdk/sky130A/libs.tech/xschem/sky130_tests/test_bipolar.sch
.subckt test_bipolar
XQ1 net3 net1 E1 sky130_fd_pr__pnp_05v5_W3p40L3p40 m=1 mult=1
Vc1 net3 0 0
.save i(vc1)
Vb1 net1 0 0
.save i(vb1)
I0 0 net4 1u
Ve1 net4 E1 0
.save i(ve1)
.save v(e1)
.save v(net1)
Ve2 net5 0 0
.save i(ve2)
Vc2 B2 net6 0
.save i(vc2)
Vb2 B2 net2 0
.save i(vb2)
XQ2 net6 net2 net5 0 sky130_fd_pr__npn_05v5_w1p00l2p00 m=1 mult=1
F1 0 B2 Ve1 1
.ends

* expanding   symbol:  sky130_tests/test_diode.sym # of pins=0
** sym_path: /pdk/sky130A/libs.tech/xschem/sky130_tests/test_diode.sym
** sch_path: /pdk/sky130A/libs.tech/xschem/sky130_tests/test_diode.sch
.subckt test_diode
I1 net1 0 dc 0 pwl 0 0 5n 0 6n 10u 10n 10u 12n -10u 16n -10u 17n 0
XD1 0 K1 sky130_fd_pr__diode_pw2nd_05v5 area=1e12 perim=4e6
Vk2 net2 K2 0
.save i(vk2)
XD2 0 K2 sky130_fd_pr__diode_pw2nd_11v0 area=1e12 perim=4e6
F1 0 net2 vk1 1
Vk1 net1 K1 0
.save i(vk1)
**** begin user architecture code

.control
save all
dc i1 1p 50u 0.1u
write test_diode.raw
set appendwrite
tran 100p 22n
write test_diode.raw
.endc

**** end user architecture code
**** begin user architecture code

**** end user architecture code
**** begin user architecture code
.lib /pdk/sky130A/libs.tech/combined/sky130.lib.spice tt
**** end user architecture code
XD3 0 K3 sky130_fd_pr__photodiode area=1e12 perim=4e6
Vk3 net3 K3 0
.save i(vk3)
F2 0 net3 vk1 1
.ends

* expanding   symbol:  sky130_tests/test_comparator.sym # of pins=0
** sym_path: /pdk/sky130A/libs.tech/xschem/sky130_tests/test_comparator.sym
** sch_path: /pdk/sky130A/libs.tech/xschem/sky130_tests/test_comparator.sch
.subckt test_comparator
*.ipin CAL
*.ipin PLUS
*.ipin MINUS
*.ipin EN
*.ipin VSS
*.ipin VCC
*.opin SAOUT
C38 VSS 0 2p
C3 SAOUTF 0 15f
C30 SN 0 2f
C1 OUTDIFF 0 15f
vndiff net1 VSSI 0
.save i(vndiff)
v3 net4 VSSI 0
.save i(v3)
v4 net3 VSSI 0
.save i(v4)
v6 net2 VSSI 0
.save i(v6)
C13 SAOUT 0 15f
v1 net5 VSSI 0
.save i(v1)
v5 net6 VSSI 0
.save i(v5)
C7 GN1 0 4f
x4 CALBB CALB VCC VSS not W_N=1 L_N=0.15 W_P=2 L_P=0.15
x5 CALB CAL VCC VSS not W_N=1 L_N=0.15 W_P=2 L_P=0.15
XM4 SP VSS net7 VCC sky130_fd_pr__pfet_01v8 L=2 W=1.2 nf=1 ad=0.348 as=0.348 pd=2.98 ps=2.98 nrd=0.241666666666667
+ nrs=0.241666666666667 sa=0 sb=0 sd=0 mult=1
XM5 GP2 GP2 VCC VCC sky130_fd_pr__pfet_01v8_lvt L=2 W=2 nf=1 ad=0.58 as=0.58 pd=4.58 ps=4.58 nrd=0.145 nrs=0.145 sa=0 sb=0 sd=0
+ mult=1
XM6 GP1 GP1 VCC VCC sky130_fd_pr__pfet_01v8_lvt L=2 W=2 nf=1 ad=0.58 as=0.58 pd=4.58 ps=4.58 nrd=0.145 nrs=0.145 sa=0 sb=0 sd=0
+ mult=1
XM8 SAOUTF OUTDIFF VCC VCC sky130_fd_pr__pfet_01v8_lvt L=2 W=2 nf=1 ad=0.58 as=0.58 pd=4.58 ps=4.58 nrd=0.145 nrs=0.145 sa=0 sb=0
+ sd=0 mult=1
XM9 SAOUT SAOUTF VCC VCC sky130_fd_pr__pfet_01v8_lvt L=2 W=2 nf=1 ad=0.58 as=0.58 pd=4.58 ps=4.58 nrd=0.145 nrs=0.145 sa=0 sb=0
+ sd=0 mult=1
XM11 SAOUT EN VCC VCC sky130_fd_pr__pfet_01v8 L=0.15 W=1 nf=1 ad=0.29 as=0.29 pd=2.58 ps=2.58 nrd=0.29 nrs=0.29 sa=0 sb=0 sd=0
+ mult=1
XM1 VSSI EN VSS VSS sky130_fd_pr__nfet_01v8 L=0.15 W=8 nf=1 ad=2.32 as=2.32 pd=16.58 ps=16.58 nrd=0.03625 nrs=0.03625 sa=0 sb=0
+ sd=0 mult=2 m=2
XM15 SAOUT SAOUTF net5 VSS sky130_fd_pr__nfet_01v8_lvt L=2 W=1 nf=1 ad=0.29 as=0.29 pd=2.58 ps=2.58 nrd=0.29 nrs=0.29 sa=0 sb=0
+ sd=0 mult=1
XM10 SAOUTF OUTDIFF net4 VSS sky130_fd_pr__nfet_01v8_lvt L=2 W=1 nf=1 ad=0.29 as=0.29 pd=2.58 ps=2.58 nrd=0.29 nrs=0.29 sa=0 sb=0
+ sd=0 mult=1
XM17 SN VCC net1 VSS sky130_fd_pr__nfet_01v8_lvt L=7 W=0.7 nf=1 ad=0.203 as=0.203 pd=1.98 ps=1.98 nrd=0.414285714285714
+ nrs=0.414285714285714 sa=0 sb=0 sd=0 mult=1
XM18 GN2 GN2 VSSI VSS sky130_fd_pr__nfet_01v8_lvt L=2 W=1 nf=1 ad=0.29 as=0.29 pd=2.58 ps=2.58 nrd=0.29 nrs=0.29 sa=0 sb=0 sd=0
+ mult=1
XM19 GN1 GN1 VSSI VSS sky130_fd_pr__nfet_01v8_lvt L=2 W=1 nf=1 ad=0.29 as=0.29 pd=2.58 ps=2.58 nrd=0.29 nrs=0.29 sa=0 sb=0 sd=0
+ mult=1
XM20 GN2 MINUS SP VCC sky130_fd_pr__pfet_01v8_lvt L=2 W=6 nf=1 ad=1.74 as=1.74 pd=12.58 ps=12.58 nrd=0.0483333333333333
+ nrs=0.0483333333333333 sa=0 sb=0 sd=0 mult=1
XM21 GN1 PLUS SP VCC sky130_fd_pr__pfet_01v8_lvt L=2 W=6 nf=1 ad=1.74 as=1.74 pd=12.58 ps=12.58 nrd=0.0483333333333333
+ nrs=0.0483333333333333 sa=0 sb=0 sd=0 mult=1
XM23 GP2 MINUS SN VSS sky130_fd_pr__nfet_01v8 L=2 W=2 nf=1 ad=0.58 as=0.58 pd=4.58 ps=4.58 nrd=0.145 nrs=0.145 sa=0 sb=0 sd=0
+ mult=1
XM16 GP1 PLUS SN VSS sky130_fd_pr__nfet_01v8 L=2 W=2 nf=1 ad=0.58 as=0.58 pd=4.58 ps=4.58 nrd=0.145 nrs=0.145 sa=0 sb=0 sd=0
+ mult=1
x1 OUTDIFF ZERO0 CALB CALBB VCC VSS passgate W_N=0.42 L_N=0.15 W_P=0.7 L_P=0.15
x2 SAOUTF ZERO1 CALB CALBB VCC VSS passgate W_N=0.42 L_N=0.15 W_P=0.7 L_P=0.15
x3 SAOUT ZERO2 CALB CALBB VCC VSS passgate W_N=0.42 L_N=0.15 W_P=0.7 L_P=0.15
C8 GN2 0 4f
C9 GP1 0 4f
C10 GP2 0 4f
XM22 GP1 GN2 VSSI VSS sky130_fd_pr__nfet_01v8_lvt L=2 W=1 nf=1 ad=0.29 as=0.29 pd=2.58 ps=2.58 nrd=0.29 nrs=0.29 sa=0 sb=0 sd=0
+ mult=1
XM25 OUTDIFF GN1 net8 VSS sky130_fd_pr__nfet_01v8_lvt L=2 W=1 nf=1 ad=0.29 as=0.29 pd=2.58 ps=2.58 nrd=0.29 nrs=0.29 sa=0 sb=0
+ sd=0 mult=1
XM26 OUTDIFF GP1 VCC VCC sky130_fd_pr__pfet_01v8_lvt L=2 W=2 nf=1 ad=0.58 as=0.58 pd=4.58 ps=4.58 nrd=0.145 nrs=0.145 sa=0 sb=0
+ sd=0 mult=1
XC5 ZERO2 VSS sky130_fd_pr__cap_mim_m3_1 W=4 L=5 MF=1
XC2 ZERO1 VSS sky130_fd_pr__cap_mim_m3_1 W=4 L=5 MF=1
XC4 ZERO0 VSS sky130_fd_pr__cap_mim_m3_1 W=4 L=5 MF=1
XM3 SAOUTF ZERO1 net3 VSS sky130_fd_pr__nfet_01v8_lvt L=3 W=1 nf=1 ad=0.29 as=0.29 pd=2.58 ps=2.58 nrd=0.29 nrs=0.29 sa=0 sb=0
+ sd=0 mult=1
XM13 SAOUTF ZERO1 VCC VCC sky130_fd_pr__pfet_01v8_lvt L=3 W=3 nf=1 ad=0.87 as=0.87 pd=6.58 ps=6.58 nrd=0.0966666666666667
+ nrs=0.0966666666666667 sa=0 sb=0 sd=0 mult=1
XM7 SAOUT ZERO2 net6 VSS sky130_fd_pr__nfet_01v8_lvt L=3 W=1 nf=1 ad=0.29 as=0.29 pd=2.58 ps=2.58 nrd=0.29 nrs=0.29 sa=0 sb=0 sd=0
+ mult=1
XM12 SAOUT ZERO2 VCC VCC sky130_fd_pr__pfet_01v8_lvt L=3 W=3 nf=1 ad=0.87 as=0.87 pd=6.58 ps=6.58 nrd=0.0966666666666667
+ nrs=0.0966666666666667 sa=0 sb=0 sd=0 mult=1
XM2 OUTDIFF ZERO0 net2 VSS sky130_fd_pr__nfet_01v8_lvt L=3 W=1 nf=1 ad=0.29 as=0.29 pd=2.58 ps=2.58 nrd=0.29 nrs=0.29 sa=0 sb=0
+ sd=0 mult=1
XM14 OUTDIFF ZERO0 VCC VCC sky130_fd_pr__pfet_01v8_lvt L=3 W=3 nf=1 ad=0.87 as=0.87 pd=6.58 ps=6.58 nrd=0.0966666666666667
+ nrs=0.0966666666666667 sa=0 sb=0 sd=0 mult=1
XM27 GN1 GP2 VCC VCC sky130_fd_pr__pfet_01v8_lvt L=2 W=2 nf=1 ad=0.58 as=0.58 pd=4.58 ps=4.58 nrd=0.145 nrs=0.145 sa=0 sb=0 sd=0
+ mult=1
vpdiff VCC net7 0
.save i(vpdiff)
VVSS net9 0 0
R1 VSS net9 30
C6 VSS 0 100p
VVCC net10 0 'VCC'
R2 VCC net10 30
C11 VCC 0 100p
VPLUS PLUS 0 'VDL'
VMINUS MINUS 0 pwl 0 'VDL' 70.2n 'VDL' 70.5n 'VDL-DELTA' 109.9n 'VDL-DELTA' 110.1n 'VDL' 170.2n 'VDL' 170.5n 'VDL+DELTA' 209.9n 'VDL+DELTA'
+ 210.1n 'VDL'
VCAL CAL 0 dc 'VCC' pwl 0 0 29.9n 0 30.1n 'VCC' 69.9n 'VCC' 70.1n 0 129.9n 0 130.1n 'VCC' 169.9n 'VCC' 170.1n 0
VEN EN 0 dc 'VCC' pwl 0 0 29.9n 0 30.1n 'VCC' 109.9n 'VCC' 110.1n 0 129.9n 0 130.1n 'VCC' 209.9n 'VCC' 210.1n 0
E5 TEMPERAT VSS VOL=' temper '
* noconn TEMPERAT
v2 net8 VSSI 0
.save i(v2)
.ends

* expanding   symbol:  sky130_tests/gates.sym # of pins=0
** sym_path: /pdk/sky130A/libs.tech/xschem/sky130_tests/gates.sym
** sch_path: /pdk/sky130A/libs.tech/xschem/sky130_tests/gates.sch
.subckt gates
x1 x1_Y x1_A x1_B VCC VSS VCC VSS NAND2
x2 x2_Y x2_A x2_B VCC VSS VCC VSS NOR2
x3 x3_Y x3_A x3_B x3_C VCC VSS VCC VSS AOI21
x4 x4_Q x4_D x4_C x4_R VCC VSS VCC VSS DFFR
x5 x5_Y x5_A x5_B VCC VSS VCC VSS AND2
x6 x6_Q x6_D x6_C x6_R VCC VSS VCC VSS DFFIR
x7 x7_Y x7_A x7_B VCC VSS VCC VSS AND2I
x8 x8_Y x8_A x8_B x8_C VCC VSS VCC VSS AND3
x9 x9_Y x9_A x9_B x9_C x9_D VCC VSS VCC VSS AND4
x10 x10_Y x10_A x10_B x10_C x10_D x10_E VCC VSS VCC VSS AND5
x11 x11_Y x11_A x11_B x11_C x11_D x11_E x11_F x11_G x11_H VCC VSS VCC VSS AND8
x12 x12_Y x12_A x12_B VCC VSS VCC VSS NAND2I
x13 x13_Y x13_A x13_B x13_C VCC VSS VCC VSS NAND3
x14 x14_Y x14_A x14_B x14_C x14_D VCC VSS VCC VSS NAND4
x15 x15_Y x15_A x15_B x15_C x15_D x15_E VCC VSS VCC VSS NAND5
x16 x16_Y x16_A x16_B x16_C x16_D x16_E x16_F x16_G x16_H VCC VSS VCC VSS NAND8
x17 x17_Y x17_A x17_B x17_C x17_D VCC VSS VCC VSS AOI22
x18 x18_Y x18_A x18_B x18_C VCC VSS VCC VSS NOR3
x19 x19_Y x19_A x19_B x19_C x19_D VCC VSS VCC VSS NOR4
x20 x20_Y x20_A x20_B x20_C x20_D x20_E VCC VSS VCC VSS NOR5
x21 x21_Y x21_A x21_B VCC VSS VCC VSS NOR2I
x22 x22_Y x22_A x22_B x22_C x22_D x22_E x22_F x22_G x22_H VCC VSS VCC VSS NOR8
x23 x23_Y x23_A x23_B x23_C VCC VSS VCC VSS OAI21
x24 x24_Y x24_A x24_B x24_C x24_D VCC VSS VCC VSS OAI22
x25 x25_Y x25_A x25_B VCC VSS VCC VSS OR2
x26 x26_Y x26_A x26_B x26_C VCC VSS VCC VSS OR3
x27 x27_Y x27_A x27_B x27_C x27_D VCC VSS VCC VSS OR4
x28 x28_Y x28_A x28_B x28_C x28_D x28_E VCC VSS VCC VSS OR5
x29 x29_Y x29_A x29_B VCC VSS VCC VSS OR2I
x30 x30_Y x30_A x30_B x30_C x30_D x30_E x30_F x30_G x30_H VCC VSS VCC VSS OR8
x31 x31_Y x31_A x31_B x31_C VCC VSS VCC VSS AO21
x32 x32_Y x32_A x32_B x32_C x32_D VCC VSS VCC VSS AO22
x33 x33_Y x33_A x33_B x33_C VCC VSS VCC VSS OA21
x34 x34_Y x34_A x34_B x34_C x34_D VCC VSS VCC VSS OA22
x35 x35_Y x35_A VCC VSS VCC VSS INV
x36 x36_Y x36_A VCC VSS VCC VSS BUF
x37 x37_Y x37_A x37_E VCC VSS VCC VSS TBUF
x39 x39_Y x39_A x39_E VCC VSS VCC VSS TBUFI
x38 x38_Y x38_A x38_B x38_C VCC VSS VCC VSS MUX2
x40 x40_Y x40_A x40_B x40_C VCC VSS VCC VSS MUX2I
x41 x41_Y x41_A x41_B x41_C x41_D x41_E x41_F VCC VSS VCC VSS MUX4
x42 x42_Y x42_A x42_B x42_C x42_D x42_E x42_F VCC VSS VCC VSS MUX4I
x43 x43_S x43_C x43_A x43_B VCC VSS VCC VSS HA
x44 x44_S x44_C x44_A x44_B x44_CI VCC VSS VCC VSS FA
x45 x45_Q x45_D x45_C VCC VSS VCC VSS DFF
x46 x46_Q x46_D x46_C VCC VSS VCC VSS DFFI
x47 x47_Q x47_D x47_C x47_S VCC VSS VCC VSS DFFIS
x48 x48_Q x48_D x48_C x48_S VCC VSS VCC VSS DFFS
x49 x49_Q x49_D x49_C x49_S x49_R VCC VSS VCC VSS DFFISR
x50 x50_Q x50_D x50_C x50_S x50_R VCC VSS VCC VSS DFFSR
x51 x51_Q x51_QB x51_D x51_C x51_R VCC VSS VCC VSS DFFRQ
x52 x52_Q x52_QB x52_D x52_C x52_R VCC VSS VCC VSS DFFIRQ
x53 x53_Q x53_QB x53_D x53_C VCC VSS VCC VSS DFFQ
x54 x54_Q x54_QB x54_D x54_C VCC VSS VCC VSS DFFIQ
x55 x55_Q x55_QB x55_D x55_C x55_S VCC VSS VCC VSS DFFISQ
x56 x56_Q x56_QB x56_D x56_C x56_S VCC VSS VCC VSS DFFSQ
x57 x57_Q x57_QB x57_D x57_C x57_S x57_R VCC VSS VCC VSS DFFISRQ
x58 x58_Q x58_QB x58_D x58_C x58_S x58_R VCC VSS VCC VSS DFFSRQ
x59 x59_Y x59_A x59_B VCC VSS VCC VSS XOR2
x60 x60_Y x60_A x60_B VCC VSS VCC VSS XNOR2
x61 x61_Q x61_D x61_E VCC VSS VCC VSS LATCH
x63 x63_Q x63_QB x63_D x63_E VCC VSS VCC VSS LATCHIQ
x64 x64_Q x64_D x64_E x64_R VCC VSS VCC VSS LATCHIR
x65 x65_Q x65_QB x65_D x65_E x65_R VCC VSS VCC VSS LATCHIRQ
x66 x66_Q x66_QB x66_D x66_E VCC VSS VCC VSS LATCHQ
x67 x67_Q x67_D x67_E x67_R VCC VSS VCC VSS LATCHR
x68 x68_Q x68_QB x68_D x68_E x68_R VCC VSS VCC VSS LATCHRQ
x69 x69_Q x69_D x69_E VCC VSS VCC VSS LATCHI
x62 x62_Q x62_D x62_E x62_S VCC VSS VCC VSS LATCHIS
x70 x70_Q x70_QB x70_D x70_E x70_S VCC VSS VCC VSS LATCHISQ
x71 x71_Q x71_D x71_E x71_S VCC VSS VCC VSS LATCHS
x72 x72_Q x72_QB x72_D x72_E x72_S VCC VSS VCC VSS LATCHSQ
x73 x73_Q x73_D x73_E x73_C VCC VSS VCC VSS EDFF
x74 x74_Q x74_QB x74_D x74_E x74_C VCC VSS VCC VSS EDFFQ
x75 x75_Q x75_SD x75_D x75_E x75_C VCC VSS VCC VSS SDFF
x76 x76_Q x76_QB x76_SD x76_D x76_E x76_C VCC VSS VCC VSS SDFFQ
.ends

* expanding   symbol:  sky130_tests/test_format_override.sym # of pins=0
** sym_path: /pdk/sky130A/libs.tech/xschem/sky130_tests/test_format_override.sym
** sch_path: /pdk/sky130A/libs.tech/xschem/sky130_tests/test_format_override.sch
.subckt test_format_override
x1 x1_A x1_B VCC VSS VCC VSS x1_Y AND2
x2 x2_Y x2_A x2_B VCC VSS VCC VSS AND2
* noconn x1_A
* noconn x1_B
* noconn x2_A
* noconn x2_B
.ends

* expanding   symbol:  sky130_tests/test_nmos_sizes.sym # of pins=0
** sym_path: /pdk/sky130A/libs.tech/xschem/sky130_tests/test_nmos_sizes.sym
** sch_path: /pdk/sky130A/libs.tech/xschem/sky130_tests/test_nmos_sizes.sch
.subckt test_nmos_sizes
XM1 D1 G 0 0 sky130_fd_pr__nfet_01v8_lvt L=L W=1 nf=1 ad=0.29 as=0.29 pd=2.58 ps=2.58 nrd=0.29 nrs=0.29 sa=0 sb=0 sd=0 mult=1
XM2 D2 G 0 0 sky130_fd_pr__nfet_01v8_lvt L=0.15 W=W nf=1 ad='int((1 + 1)/2) * W / 1 * 0.29' as='int((1 + 2)/2) * W / 1 * 0.29' pd='2*int((1 + 1)/2) * (W / 1 + 0.29)'
+ ps='2*int((1 + 2)/2) * (W / 1 + 0.29)' nrd='0.29 / W ' nrs='0.29 / W ' sa=0 sb=0 sd=0 mult=1
V2 D D2 0
.save i(v2)
V1 D D1 0
.save i(v1)
* noconn G
.ends

* expanding   symbol:  sky130_tests/gates_sky130.sym # of pins=0
** sym_path: /pdk/sky130A/libs.tech/xschem/sky130_tests/gates_sky130.sym
** sch_path: /pdk/sky130A/libs.tech/xschem/sky130_tests/gates_sky130.sch
.subckt gates_sky130
x1 A1 A2 B1 B2 C1 VGND VNB VPB VPWR X sky130_fd_sc_hd__a221o_1
x2 A1 A2 B1 B2 C1 VGND VNB VPB VPWR Y sky130_fd_sc_hd__a221oi_1
x3 A1 A2 B1 B2 VGND VNB VPB VPWR Y sky130_fd_sc_hd__a22oi_1
x4 A1 A2 B1 C1 D1 VGND VNB VPB VPWR X sky130_fd_sc_hd__a2111o_1
x5 A1 A2 B1 C1 D1 VGND VNB VPB VPWR Y sky130_fd_sc_hd__a2111oi_1
x6 A1 A2 B1 C1 VGND VNB VPB VPWR X sky130_fd_sc_hd__a211o_1
x7 A1 A2 B1 C1 VGND VNB VPB VPWR Y sky130_fd_sc_hd__a211oi_1
x8 A1 A2 B1 VGND VNB VPB VPWR X sky130_fd_sc_hd__a21o_1
x9 A1 A2 B1 B2 VGND VNB VPB VPWR X sky130_fd_sc_hd__a22o_1
x10 A1 A2 B1_N VGND VNB VPB VPWR X sky130_fd_sc_hd__a21bo_1
x11 A1 A2 B1_N VGND VNB VPB VPWR Y sky130_fd_sc_hd__a21boi_1
x12 A1 A2 B1 VGND VNB VPB VPWR Y sky130_fd_sc_hd__a21oi_1
x13 A1 A2 B1 B2 C1 C2 VGND VNB VPB VPWR Y sky130_fd_sc_hd__a222oi_1
x14 A1_N A2_N B1 B2 VGND VNB VPB VPWR X sky130_fd_sc_hd__a2bb2o_1
x15 A1_N A2_N B1 B2 VGND VNB VPB VPWR Y sky130_fd_sc_hd__a2bb2oi_1
x16 A1 A2 A3 B1 C1 VGND VNB VPB VPWR X sky130_fd_sc_hd__a311o_1
x17 A1 A2 A3 B1 C1 VGND VNB VPB VPWR Y sky130_fd_sc_hd__a311oi_1
x18 A1 A2 A3 B1 VGND VNB VPB VPWR X sky130_fd_sc_hd__a31o_1
x19 A1 A2 A3 B1 VGND VNB VPB VPWR Y sky130_fd_sc_hd__a31oi_1
x20 A1 A2 A3 B1 B2 VGND VNB VPB VPWR X sky130_fd_sc_hd__a32o_1
x21 A1 A2 A3 B1 B2 VGND VNB VPB VPWR Y sky130_fd_sc_hd__a32oi_1
x22 A1 A2 A3 A4 B1 VGND VNB VPB VPWR X sky130_fd_sc_hd__a41o_1
x23 A1 A2 A3 A4 B1 VGND VNB VPB VPWR Y sky130_fd_sc_hd__a41oi_1
x24 A B VGND VNB VPB VPWR X sky130_fd_sc_hd__and2_1
x25 A_N B VGND VNB VPB VPWR X sky130_fd_sc_hd__and2b_1
x26 A B C VGND VNB VPB VPWR X sky130_fd_sc_hd__and3_1
x27 A_N B C VGND VNB VPB VPWR X sky130_fd_sc_hd__and3b_1
x28 A B C D VGND VNB VPB VPWR X sky130_fd_sc_hd__and4_1
x29 A_N B C D VGND VNB VPB VPWR X sky130_fd_sc_hd__and4b_1
x30 A_N B_N C D VGND VNB VPB VPWR X sky130_fd_sc_hd__and4bb_1
x31 A VGND VNB VPB VPWR X sky130_fd_sc_hd__buf_1
x32 A VGND VNB VPB VPWR X sky130_fd_sc_hd__clkbuf_1
x33 A VGND VNB VPB VPWR Y sky130_fd_sc_hd__clkinv_1
x34 VGND VNB VPB VPWR HI LO sky130_fd_sc_hd__conb_1
x35 A VGND VNB VPB VPWR X sky130_fd_sc_hd__clkdlybuf4s15_1
x36 A VGND VNB VPB VPWR X sky130_fd_sc_hd__clkdlybuf4s18_1
x37 A VGND VNB VPB VPWR X sky130_fd_sc_hd__clkdlybuf4s25_1
x38 A VGND VNB VPB VPWR X sky130_fd_sc_hd__clkdlybuf4s50_1
x39 A B VGND VNB VPB VPWR Y sky130_fd_sc_hd__nand2_1
x40 A_N B VGND VNB VPB VPWR Y sky130_fd_sc_hd__nand2b_1
x41 A B C VGND VNB VPB VPWR Y sky130_fd_sc_hd__nand3_1
x42 A_N B C VGND VNB VPB VPWR Y sky130_fd_sc_hd__nand3b_1
x43 A B C D VGND VNB VPB VPWR Y sky130_fd_sc_hd__nand4_1
x44 B C D VGND VNB VPB VPWR Y sky130_fd_sc_hd__nand4b_1
x45 C D VGND VNB VPB VPWR Y sky130_fd_sc_hd__nand4bb_1
x46 A0 A1 S VGND VNB VPB VPWR X sky130_fd_sc_hd__mux2_1
x47 A0 A1 S VGND VNB VPB VPWR Y sky130_fd_sc_hd__mux2i_1
x48 A B C VGND VNB VPB VPWR X sky130_fd_sc_hd__maj3_1
x49 A0 A1 A2 A3 S0 S1 VGND VNB VPB VPWR X sky130_fd_sc_hd__mux4_1
x50 A VGND VNB VPB VPWR Y sky130_fd_sc_hd__inv_1
x51 A B CIN VGND VNB VPB VPWR COUT SUM sky130_fd_sc_hd__fa_1
x52 A B CI VGND VNB VPB VPWR COUT SUM sky130_fd_sc_hd__fah_1
x53 A VGND VNB VPB VPWR X sky130_fd_sc_hd__dlygate4sd1_1
x54 A VGND VNB VPB VPWR X sky130_fd_sc_hd__dlygate4sd2_1
x55 A VGND VNB VPB VPWR X sky130_fd_sc_hd__dlygate4sd3_1
x57 A VGND VNB VPB VPWR X sky130_fd_sc_hd__dlymetal6s2s_1
x58 A VGND VNB VPB VPWR X sky130_fd_sc_hd__dlymetal6s4s_1
x59 A VGND VNB VPB VPWR X sky130_fd_sc_hd__dlymetal6s6s_1
x60 A TE_B VGND VNB VPB VPWR Z sky130_fd_sc_hd__ebufn_1
x61 A TE_B VGND VNB VPB VPWR Z sky130_fd_sc_hd__einvn_1
x62 A B VGND VNB VPB VPWR COUT SUM sky130_fd_sc_hd__ha_1
x63 A TE VGND VNB VPB VPWR Z sky130_fd_sc_hd__einvp_1
x64 A B CIN VGND VNB VPB VPWR COUT SUM sky130_fd_sc_hd__fahcin_1
x65 A B CI VGND VNB VPB VPWR COUT_N SUM sky130_fd_sc_hd__fahcon_1
x66 A B VGND VNB VPB VPWR Y sky130_fd_sc_hd__nor2_1
x67 A B_N VGND VNB VPB VPWR Y sky130_fd_sc_hd__nor2b_1
x68 A B C VGND VNB VPB VPWR Y sky130_fd_sc_hd__nor3_1
x69 A B C_N VGND VNB VPB VPWR Y sky130_fd_sc_hd__nor3b_1
x70 A B C D VGND VNB VPB VPWR Y sky130_fd_sc_hd__nor4_1
x71 A B C D_N VGND VNB VPB VPWR Y sky130_fd_sc_hd__nor4b_1
x72 A B C_N D_N VGND VNB VPB VPWR Y sky130_fd_sc_hd__nor4bb_1
x73 A1 A2 B1 VGND VNB VPB VPWR X sky130_fd_sc_hd__o21a_1
x74 A1 A2 B1 VGND VNB VPB VPWR Y sky130_fd_sc_hd__o21ai_1
x75 A1 A2 B1 B2 VGND VNB VPB VPWR X sky130_fd_sc_hd__o22a_1
x76 A1 A2 B1 B2 VGND VNB VPB VPWR Y sky130_fd_sc_hd__o22ai_1
x77 A1 A2 B1 C1 VGND VNB VPB VPWR X sky130_fd_sc_hd__o211a_1
x78 A1 A2 B1 C1 VGND VNB VPB VPWR Y sky130_fd_sc_hd__o211ai_1
x79 A1 A2 B1_N VGND VNB VPB VPWR X sky130_fd_sc_hd__o21ba_1
x80 A1 A2 B1_N VGND VNB VPB VPWR Y sky130_fd_sc_hd__o21bai_1
x81 A1 A2 B1 B2 C1 VGND VNB VPB VPWR X sky130_fd_sc_hd__o221a_1
x82 A1 A2 B1 B2 C1 VGND VNB VPB VPWR Y sky130_fd_sc_hd__o221ai_1
x83 A1 A2 A3 B1 VGND VNB VPB VPWR X sky130_fd_sc_hd__o31a_1
x84 A1 A2 A3 B1 VGND VNB VPB VPWR Y sky130_fd_sc_hd__o31ai_1
x85 A1 A2 A3 B1 C1 VGND VNB VPB VPWR X sky130_fd_sc_hd__o311a_1
x86 A1 A2 A3 B1 C1 VGND VNB VPB VPWR Y sky130_fd_sc_hd__o311ai_1
x87 net1 net2 net3 net4 net5 VGND VNB VPB VPWR net6 sky130_fd_sc_hd__o2111a_1
x88 net7 net8 net9 net10 net11 VGND VNB VPB VPWR net12 sky130_fd_sc_hd__o2111ai_1
x89 A1_N A2_N B1 B2 VGND VNB VPB VPWR X sky130_fd_sc_hd__o2bb2a_1
x90 A1_N A2_N B1 B2 VGND VNB VPB VPWR Y sky130_fd_sc_hd__o2bb2ai_1
x91 A1 A2 A3 B1 B2 VGND VNB VPB VPWR X sky130_fd_sc_hd__o32a_1
x92 A1 A2 A3 B1 B2 VGND VNB VPB VPWR Y sky130_fd_sc_hd__o32ai_1
x93 A1 A2 A3 A4 B1 VGND VNB VPB VPWR X sky130_fd_sc_hd__o41a_1
x94 A1 A2 A3 A4 B1 VGND VNB VPB VPWR Y sky130_fd_sc_hd__o41ai_1
x95 A B VGND VNB VPB VPWR X sky130_fd_sc_hd__or2_1
x96 A B_N VGND VNB VPB VPWR X sky130_fd_sc_hd__or2b_1
x97 A B C VGND VNB VPB VPWR X sky130_fd_sc_hd__or3_1
x98 A B C_N VGND VNB VPB VPWR X sky130_fd_sc_hd__or3b_1
x99 A B C D VGND VNB VPB VPWR X sky130_fd_sc_hd__or4_1
x100 A B C D_N VGND VNB VPB VPWR X sky130_fd_sc_hd__or4b_1
x101 A B C_N D_N VGND VNB VPB VPWR X sky130_fd_sc_hd__or4bb_1
x102 A B VGND VNB VPB VPWR Y sky130_fd_sc_hd__xnor2_1
x103 A B C VGND VNB VPB VPWR X sky130_fd_sc_hd__xnor3_1
x104 A B VGND VNB VPB VPWR X sky130_fd_sc_hd__xor2_1
x105 A B C VGND VNB VPB VPWR X sky130_fd_sc_hd__xor3_1
x106 CLK_N D RESET_B SCD SCE SET_B VGND VNB VPB VPWR Q Q_N sky130_fd_sc_hd__sdfbbn_1
x107 CLK D RESET_B SCD SCE SET_B VGND VNB VPB VPWR Q Q_N sky130_fd_sc_hd__sdfbbp_1
x108 CLK D RESET_B SCD SCE VGND VNB VPB VPWR Q Q_N sky130_fd_sc_hd__sdfrbp_1
x109 CLK_N D RESET_B SCD SCE VGND VNB VPB VPWR Q sky130_fd_sc_hd__sdfrtn_1
x110 CLK D RESET_B SCD SCE VGND VNB VPB VPWR Q sky130_fd_sc_hd__sdfrtp_1
x111 CLK D SCD SCE SET_B VGND VNB VPB VPWR Q Q_N sky130_fd_sc_hd__sdfsbp_1
x112 CLK D SCD SCE SET_B VGND VNB VPB VPWR Q sky130_fd_sc_hd__sdfstp_1
x113 CLK D SCD SCE VGND VNB VPB VPWR Q Q_N sky130_fd_sc_hd__sdfxbp_1
x114 CLK GATE SCE VGND VNB VPB VPWR GCLK sky130_fd_sc_hd__sdlclkp_1
x115 CLK D DE SCD SCE VGND VNB VPB VPWR Q Q_N sky130_fd_sc_hd__sedfxbp_1
x116 CLK D DE SCD SCE VGND VNB VPB VPWR Q sky130_fd_sc_hd__sedfxtp_1
x117 CLK D SCD SCE VGND VNB VPB VPWR Q sky130_fd_sc_hd__sdfxtp_1
x118 CLK_N D RESET_B SET_B VGND VNB VPB VPWR Q Q_N sky130_fd_sc_hd__dfbbn_1
x119 CLK D RESET_B SET_B VGND VNB VPB VPWR Q Q_N sky130_fd_sc_hd__dfbbp_1
x121 CLK D RESET_B VGND VNB VPB VPWR Q sky130_fd_sc_hd__dfrtp_1
x122 CLK D SET_B VGND VNB VPB VPWR Q Q_N sky130_fd_sc_hd__dfsbp_1
x123 CLK D SET_B VGND VNB VPB VPWR Q sky130_fd_sc_hd__dfstp_1
x124 CLK D VGND VNB VPB VPWR Q Q_N sky130_fd_sc_hd__dfxbp_1
x125 CLK GATE VGND VNB VPB VPWR GCLK sky130_fd_sc_hd__dlclkp_1
x126 D GATE_N RESET_B VGND VNB VPB VPWR Q Q_N sky130_fd_sc_hd__dlrbn_1
x127 D GATE RESET_B VGND VNB VPB VPWR Q Q_N sky130_fd_sc_hd__dlrbp_1
x128 D GATE_N RESET_B VGND VNB VPB VPWR Q sky130_fd_sc_hd__dlrtn_1
x129 D GATE RESET_B VGND VNB VPB VPWR Q sky130_fd_sc_hd__dlrtp_1
x130 D GATE_N VGND VNB VPB VPWR Q Q_N sky130_fd_sc_hd__dlxbn_1
x131 D GATE VGND VNB VPB VPWR Q sky130_fd_sc_hd__dlxtp_1
x132 CLK D DE VGND VNB VPB VPWR Q Q_N sky130_fd_sc_hd__edfxbp_1
x133 CLK D DE VGND VNB VPB VPWR Q sky130_fd_sc_hd__edfxtp_1
x134 VGND VNB VPB VPWR sky130_fd_sc_hd__fill_1
x120 CLK D RESET_B VGND VNB VPB VPWR Q Q_N sky130_fd_sc_hd__dfrbp_1
x135 CLK_N D RESET_B VGND VNB VPB VPWR Q sky130_fd_sc_hd__dfrtn_1
x136 CLK D VGND VNB VPB VPWR Q sky130_fd_sc_hd__dfxtp_1
x137 D GATE_N VGND VNB VPB VPWR Q sky130_fd_sc_hd__dlxtn_1
x138 D GATE VGND VNB VPB VPWR Q sky130_fd_sc_hd__dlxtp_1
x139 VGND VNB VPB VPWR sky130_fd_sc_hd__tap_1
x141 VGND VPB VPWR sky130_fd_sc_hd__tapvgnd_1
x142 VGND VPB VPWR sky130_fd_sc_hd__tapvgnd2_1
x143 VGND VPWR sky130_fd_sc_hd__tapvpwrvgnd_1
x144 SHORT VGND VNB VPB VPWR sky130_fd_sc_hd__lpflow_bleeder_1
x145 A KAPWR VGND VNB VPB VPWR X sky130_fd_sc_hd__lpflow_clkbufkapwr_1
x146 A KAPWR VGND VNB VPB VPWR Y sky130_fd_sc_hd__lpflow_clkinvkapwr_1
x147 A SLEEP_B VGND VNB VPB VPWR X sky130_fd_sc_hd__lpflow_inputiso0n_1
x148 A SLEEP VGND VNB VPB VPWR X sky130_fd_sc_hd__lpflow_inputiso0p_1
x149 A SLEEP_B VGND VNB VPB VPWR X sky130_fd_sc_hd__lpflow_inputiso1n_1
x150 A SLEEP VGND VNB VPB VPWR X sky130_fd_sc_hd__lpflow_inputiso1p_1
x151 D SLEEP_B VGND VNB VPB VPWR Q sky130_fd_sc_hd__lpflow_inputisolatch_1
x152 A SLEEP VGND VNB VPB VPWR X sky130_fd_sc_hd__lpflow_isobufsrc_1
x153 A LOWLVPWR VGND VPB VPWR X sky130_fd_sc_hd__lpflow_lsbuf_lh_isowell_tap_1
x154 A VGND VPB VPWRIN VPWR X sky130_fd_sc_hd__lpflow_lsbuf_lh_hl_isowell_tap_1
x155 VGND VNB VPB VPWR LO sky130_fd_sc_hd__macro_sparecell
x156 A VGND VNB VPB VPWR Y sky130_fd_sc_hd__clkinvlp_2
x157 A LOWLVPWR VGND VPB VPWR X sky130_fd_sc_hd__lpflow_lsbuf_lh_isowell_tap_4
x158 DIODE VGND VNB VPB VPWR sky130_fd_sc_hd__diode_2
x159 KAPWR VGND VNB VPB VPWR sky130_fd_sc_hd__lpflow_decapkapwr_3
x160 A SLEEP KAPWR VGND VNB VPB VPWR X sky130_fd_sc_hd__lpflow_isobufsrckapwr_16
x161 VGND VNB VPB VPWR sky130_fd_sc_hd__decap_3
x162 A VGND VNB VPB VPWR X sky130_fd_sc_hd__bufbuf_8
x163 A VGND VNB VPB VPWR Y sky130_fd_sc_hd__bufinv_8
x164 A VGND VNB VPB VPWR X sky130_fd_sc_hd__probe_p_8
x165 A VGND VNB VPB VPWR X sky130_fd_sc_hd__probec_p_8
.ends

* expanding   symbol:  sky130_tests/test_stdcells.sym # of pins=0
** sym_path: /pdk/sky130A/libs.tech/xschem/sky130_tests/test_stdcells.sym
** sch_path: /pdk/sky130A/libs.tech/xschem/sky130_tests/test_stdcells.sch
.subckt test_stdcells
V1 A 0 pulse 0 'vcc' '0.495/ 0.09e9 ' '0.01/0.09e9 ' '0.01/0.09e9 ' '0.49/0.09e9 ' '1/0.09e9 '
V2 B 0 pulse 0 'vcc' '0.495/ 0.02e9 ' '0.01/0.02e9 ' '0.01/0.02e9 ' '0.49/0.02e9 ' '1/0.02e9 '
V3 CLK 0 pulse 0 'vcc' '0.495/ 0.2e9 ' '0.01/0.2e9 ' '0.01/0.2e9 ' '0.49/0.2e9 ' '1/0.2e9 '
V4 RESET_B 0 pulse 0 'vcc' '0.495/ 0.7e8 ' '0.01/0.7e8 ' '0.01/0.7e8 ' '0.49/0.7e8 ' '1/0.7e8 '
x2 QLATCH A X B Y CLK Q RESET_B XSCHEM VCC VSS stdcells
x1 X_QLATCH A X_X B X_Y CLK X_Q RESET_B X_XSCHEM VCC VSS stdcells_xspice
* noconn VCC
* noconn VSS
C1 X_QLATCH 0 4f
C2 X_X 0 4f
C3 X_Y 0 4f
C4 X_Q 0 4f
C5 X_XSCHEM 0 4f
.ends

* expanding   symbol:  sky130_tests/all_sky130_gates.sym # of pins=0
** sym_path: /pdk/sky130A/libs.tech/xschem/sky130_tests/all_sky130_gates.sym
** sch_path: /pdk/sky130A/libs.tech/xschem/sky130_tests/all_sky130_gates.sch
.subckt all_sky130_gates
x1 net1 net2 net3 net4 net5 GND GND VCC VCC net6 sky130_fd_sc_hd__a2111o_1
x2 net7 net8 net9 net10 net11 GND GND VCC VCC net12 sky130_fd_sc_hd__a2111o_2
x3 net13 net14 net15 net16 net17 GND GND VCC VCC net18 sky130_fd_sc_hd__a2111o_4
x4 net19 net20 net21 net22 net23 GND GND VCC VCC net24 sky130_fd_sc_hd__a2111oi_0
x5 net25 net26 net27 net28 net29 GND GND VCC VCC net30 sky130_fd_sc_hd__a2111oi_1
x6 net31 net32 net33 net34 net35 GND GND VCC VCC net36 sky130_fd_sc_hd__a2111oi_2
x7 net37 net38 net39 net40 net41 GND GND VCC VCC net42 sky130_fd_sc_hd__a2111oi_4
x8 net43 net44 net45 net46 GND GND VCC VCC net47 sky130_fd_sc_hd__a211o_1
x9 net48 net49 net50 net51 GND GND VCC VCC net52 sky130_fd_sc_hd__a211o_2
x10 net53 net54 net55 net56 GND GND VCC VCC net57 sky130_fd_sc_hd__a211o_4
x11 net58 net59 net60 net61 GND GND VCC VCC net62 sky130_fd_sc_hd__a211oi_1
x12 net63 net64 net65 net66 GND GND VCC VCC net67 sky130_fd_sc_hd__a211oi_2
x13 net68 net69 net70 net71 GND GND VCC VCC net72 sky130_fd_sc_hd__a211oi_4
x14 net73 net74 net75 GND GND VCC VCC net76 sky130_fd_sc_hd__a21bo_1
x15 net77 net78 net79 GND GND VCC VCC net80 sky130_fd_sc_hd__a21bo_2
x16 net81 net82 net83 GND GND VCC VCC net84 sky130_fd_sc_hd__a21bo_4
x17 net85 net86 net87 GND GND VCC VCC net88 sky130_fd_sc_hd__a21boi_0
x18 net89 net90 net91 GND GND VCC VCC net92 sky130_fd_sc_hd__a21boi_1
x19 net93 net94 net95 GND GND VCC VCC net96 sky130_fd_sc_hd__a21boi_2
x20 net97 net98 net99 GND GND VCC VCC net100 sky130_fd_sc_hd__a21boi_4
x21 net101 net102 net103 GND GND VCC VCC net104 sky130_fd_sc_hd__a21o_1
x22 net105 net106 net107 GND GND VCC VCC net108 sky130_fd_sc_hd__a21o_2
x23 net109 net110 net111 GND GND VCC VCC net112 sky130_fd_sc_hd__a21o_4
x24 net113 net114 net115 GND GND VCC VCC net116 sky130_fd_sc_hd__a21oi_1
x25 net117 net118 net119 GND GND VCC VCC net120 sky130_fd_sc_hd__a21oi_2
x26 net121 net122 net123 GND GND VCC VCC net124 sky130_fd_sc_hd__a21oi_4
x27 net125 net126 net127 net128 net129 GND GND VCC VCC net130 sky130_fd_sc_hd__a221o_1
x28 net131 net132 net133 net134 net135 GND GND VCC VCC net136 sky130_fd_sc_hd__a221o_2
x29 net137 net138 net139 net140 net141 GND GND VCC VCC net142 sky130_fd_sc_hd__a221o_4
x30 net143 net144 net145 net146 net147 GND GND VCC VCC net148 sky130_fd_sc_hd__a221oi_1
x31 net149 net150 net151 net152 net153 GND GND VCC VCC net154 sky130_fd_sc_hd__a221oi_2
x32 net155 net156 net157 net158 net159 GND GND VCC VCC net160 sky130_fd_sc_hd__a221oi_4
x33 net161 net162 net163 net164 net165 net166 GND GND VCC VCC net167 sky130_fd_sc_hd__a222oi_1
x34 net168 net169 net170 net171 GND GND VCC VCC net172 sky130_fd_sc_hd__a22o_1
x35 net173 net174 net175 net176 GND GND VCC VCC net177 sky130_fd_sc_hd__a22o_2
x36 net178 net179 net180 net181 GND GND VCC VCC net182 sky130_fd_sc_hd__a22o_4
x37 net183 net184 net185 net186 GND GND VCC VCC net187 sky130_fd_sc_hd__a22oi_1
x38 net188 net189 net190 net191 GND GND VCC VCC net192 sky130_fd_sc_hd__a22oi_2
x39 net193 net194 net195 net196 GND GND VCC VCC net197 sky130_fd_sc_hd__a22oi_4
x40 net198 net199 net200 net201 GND GND VCC VCC net202 sky130_fd_sc_hd__a2bb2o_1
x41 net203 net204 net205 net206 GND GND VCC VCC net207 sky130_fd_sc_hd__a2bb2o_2
x42 net208 net209 net210 net211 GND GND VCC VCC net212 sky130_fd_sc_hd__a2bb2o_4
x43 net213 net214 net215 net216 GND GND VCC VCC net217 sky130_fd_sc_hd__a2bb2oi_1
x44 net218 net219 net220 net221 GND GND VCC VCC net222 sky130_fd_sc_hd__a2bb2oi_2
x45 net223 net224 net225 net226 GND GND VCC VCC net227 sky130_fd_sc_hd__a2bb2oi_4
x46 net228 net229 net230 net231 net232 GND GND VCC VCC net233 sky130_fd_sc_hd__a311o_1
x47 net234 net235 net236 net237 net238 GND GND VCC VCC net239 sky130_fd_sc_hd__a311o_2
x48 net240 net241 net242 net243 net244 GND GND VCC VCC net245 sky130_fd_sc_hd__a311o_4
x49 net246 net247 net248 net249 net250 GND GND VCC VCC net251 sky130_fd_sc_hd__a311oi_1
x50 net252 net253 net254 net255 net256 GND GND VCC VCC net257 sky130_fd_sc_hd__a311oi_2
x51 net258 net259 net260 net261 net262 GND GND VCC VCC net263 sky130_fd_sc_hd__a311oi_4
x52 net264 net265 net266 net267 GND GND VCC VCC net268 sky130_fd_sc_hd__a31o_1
x53 net269 net270 net271 net272 GND GND VCC VCC net273 sky130_fd_sc_hd__a31o_2
x54 net274 net275 net276 net277 GND GND VCC VCC net278 sky130_fd_sc_hd__a31o_4
x55 net279 net280 net281 net282 GND GND VCC VCC net283 sky130_fd_sc_hd__a31oi_1
x56 net284 net285 net286 net287 GND GND VCC VCC net288 sky130_fd_sc_hd__a31oi_2
x57 net289 net290 net291 net292 GND GND VCC VCC net293 sky130_fd_sc_hd__a31oi_4
x58 net294 net295 net296 net297 net298 GND GND VCC VCC net299 sky130_fd_sc_hd__a32o_1
x59 net300 net301 net302 net303 net304 GND GND VCC VCC net305 sky130_fd_sc_hd__a32o_2
x60 net306 net307 net308 net309 net310 GND GND VCC VCC net311 sky130_fd_sc_hd__a32o_4
x61 net312 net313 net314 net315 net316 GND GND VCC VCC net317 sky130_fd_sc_hd__a32oi_1
x62 net318 net319 net320 net321 net322 GND GND VCC VCC net323 sky130_fd_sc_hd__a32oi_2
x63 net324 net325 net326 net327 net328 GND GND VCC VCC net329 sky130_fd_sc_hd__a32oi_4
x64 net330 net331 net332 net333 net334 GND GND VCC VCC net335 sky130_fd_sc_hd__a41o_1
x65 net336 net337 net338 net339 net340 GND GND VCC VCC net341 sky130_fd_sc_hd__a41o_2
x66 net342 net343 net344 net345 net346 GND GND VCC VCC net347 sky130_fd_sc_hd__a41o_4
x67 net348 net349 net350 net351 net352 GND GND VCC VCC net353 sky130_fd_sc_hd__a41oi_1
x68 net354 net355 net356 net357 net358 GND GND VCC VCC net359 sky130_fd_sc_hd__a41oi_2
x69 net360 net361 net362 net363 net364 GND GND VCC VCC net365 sky130_fd_sc_hd__a41oi_4
x70 net366 net367 GND GND VCC VCC net368 sky130_fd_sc_hd__and2_0
x71 net369 net370 GND GND VCC VCC net371 sky130_fd_sc_hd__and2_1
x72 net372 net373 GND GND VCC VCC net374 sky130_fd_sc_hd__and2_2
x73 net375 net376 GND GND VCC VCC net377 sky130_fd_sc_hd__and2_4
x74 net378 net379 GND GND VCC VCC net380 sky130_fd_sc_hd__and2b_1
x75 net381 net382 GND GND VCC VCC net383 sky130_fd_sc_hd__and2b_2
x76 net384 net385 GND GND VCC VCC net386 sky130_fd_sc_hd__and2b_4
x77 net387 net388 net389 GND GND VCC VCC net390 sky130_fd_sc_hd__and3_1
x78 net391 net392 net393 GND GND VCC VCC net394 sky130_fd_sc_hd__and3_2
x79 net395 net396 net397 GND GND VCC VCC net398 sky130_fd_sc_hd__and3_4
x80 net399 net400 net401 GND GND VCC VCC net402 sky130_fd_sc_hd__and3b_1
x81 net403 net404 net405 GND GND VCC VCC net406 sky130_fd_sc_hd__and3b_2
x82 net407 net408 net409 GND GND VCC VCC net410 sky130_fd_sc_hd__and3b_4
x83 net411 net412 net413 net414 GND GND VCC VCC net415 sky130_fd_sc_hd__and4_1
x84 net416 net417 net418 net419 GND GND VCC VCC net420 sky130_fd_sc_hd__and4_2
x85 net421 net422 net423 net424 GND GND VCC VCC net425 sky130_fd_sc_hd__and4_4
x86 net426 net427 net428 net429 GND GND VCC VCC net430 sky130_fd_sc_hd__and4b_1
x87 net431 net432 net433 net434 GND GND VCC VCC net435 sky130_fd_sc_hd__and4b_2
x88 net436 net437 net438 net439 GND GND VCC VCC net440 sky130_fd_sc_hd__and4b_4
x89 net441 net442 net443 net444 GND GND VCC VCC net445 sky130_fd_sc_hd__and4bb_1
x90 net446 net447 net448 net449 GND GND VCC VCC net450 sky130_fd_sc_hd__and4bb_2
x91 net451 net452 net453 net454 GND GND VCC VCC net455 sky130_fd_sc_hd__and4bb_4
x92 net456 GND GND VCC VCC net457 sky130_fd_sc_hd__buf_12
x93 net458 GND GND VCC VCC net459 sky130_fd_sc_hd__buf_16
x94 net460 GND GND VCC VCC net461 sky130_fd_sc_hd__buf_1
x95 net462 GND GND VCC VCC net463 sky130_fd_sc_hd__buf_2
x96 net464 GND GND VCC VCC net465 sky130_fd_sc_hd__buf_4
x97 net466 GND GND VCC VCC net467 sky130_fd_sc_hd__buf_6
x98 net468 GND GND VCC VCC net469 sky130_fd_sc_hd__buf_8
x99 net470 GND GND VCC VCC net471 sky130_fd_sc_hd__bufbuf_16
x100 net472 GND GND VCC VCC net473 sky130_fd_sc_hd__bufbuf_8
x101 net474 GND GND VCC VCC net475 sky130_fd_sc_hd__bufinv_16
x102 net476 GND GND VCC VCC net477 sky130_fd_sc_hd__bufinv_8
x103 net478 GND GND VCC VCC net479 sky130_fd_sc_hd__clkbuf_16
x104 net480 GND GND VCC VCC net481 sky130_fd_sc_hd__clkbuf_1
x105 net482 GND GND VCC VCC net483 sky130_fd_sc_hd__clkbuf_2
x106 net484 GND GND VCC VCC net485 sky130_fd_sc_hd__clkbuf_4
x107 net486 GND GND VCC VCC net487 sky130_fd_sc_hd__clkbuf_8
x108 net488 GND GND VCC VCC net489 sky130_fd_sc_hd__clkdlybuf4s15_1
x109 net490 GND GND VCC VCC net491 sky130_fd_sc_hd__clkdlybuf4s15_2
x110 net492 GND GND VCC VCC net493 sky130_fd_sc_hd__clkdlybuf4s18_1
x111 net494 GND GND VCC VCC net495 sky130_fd_sc_hd__clkdlybuf4s18_2
x112 net496 GND GND VCC VCC net497 sky130_fd_sc_hd__clkdlybuf4s25_1
x113 net498 GND GND VCC VCC net499 sky130_fd_sc_hd__clkdlybuf4s25_2
x114 net500 GND GND VCC VCC net501 sky130_fd_sc_hd__clkdlybuf4s50_1
x115 net502 GND GND VCC VCC net503 sky130_fd_sc_hd__clkdlybuf4s50_2
x116 net504 GND GND VCC VCC net505 sky130_fd_sc_hd__clkinv_16
x117 net506 GND GND VCC VCC net507 sky130_fd_sc_hd__clkinv_1
x118 net508 GND GND VCC VCC net509 sky130_fd_sc_hd__clkinv_2
x119 net510 GND GND VCC VCC net511 sky130_fd_sc_hd__clkinv_4
x120 net512 GND GND VCC VCC net513 sky130_fd_sc_hd__clkinv_8
x121 net514 GND GND VCC VCC net515 sky130_fd_sc_hd__clkinvlp_2
x122 net516 GND GND VCC VCC net517 sky130_fd_sc_hd__clkinvlp_4
x123 GND GND VCC VCC net518 net519 sky130_fd_sc_hd__conb_1
x124 GND GND VCC VCC sky130_fd_sc_hd__decap_12
x125 GND GND VCC VCC sky130_fd_sc_hd__decap_3
x126 GND GND VCC VCC sky130_fd_sc_hd__decap_4
x127 GND GND VCC VCC sky130_fd_sc_hd__decap_6
x128 GND GND VCC VCC sky130_fd_sc_hd__decap_8
x129 net520 net521 net522 net523 GND GND VCC VCC net524 net525 sky130_fd_sc_hd__dfbbn_1
x130 net526 net527 net528 net529 GND GND VCC VCC net530 net531 sky130_fd_sc_hd__dfbbn_2
x131 net532 net533 net534 net535 GND GND VCC VCC net536 net537 sky130_fd_sc_hd__dfbbp_1
x132 net538 net539 net540 GND GND VCC VCC net541 net542 sky130_fd_sc_hd__dfrbp_1
x133 net543 net544 net545 GND GND VCC VCC net546 net547 sky130_fd_sc_hd__dfrbp_2
x134 net548 net549 net550 GND GND VCC VCC net551 sky130_fd_sc_hd__dfrtn_1
x135 net552 net553 net554 GND GND VCC VCC net555 sky130_fd_sc_hd__dfrtp_1
x136 net556 net557 net558 GND GND VCC VCC net559 sky130_fd_sc_hd__dfrtp_2
x137 net560 net561 net562 GND GND VCC VCC net563 sky130_fd_sc_hd__dfrtp_4
x138 net564 net565 net566 GND GND VCC VCC net567 net568 sky130_fd_sc_hd__dfsbp_1
x139 net569 net570 net571 GND GND VCC VCC net572 net573 sky130_fd_sc_hd__dfsbp_2
x140 net574 net575 net576 GND GND VCC VCC net577 sky130_fd_sc_hd__dfstp_1
x141 net578 net579 net580 GND GND VCC VCC net581 sky130_fd_sc_hd__dfstp_2
x142 net582 net583 net584 GND GND VCC VCC net585 sky130_fd_sc_hd__dfstp_4
x143 net586 net587 GND GND VCC VCC net588 net589 sky130_fd_sc_hd__dfxbp_1
x144 net590 net591 GND GND VCC VCC net592 net593 sky130_fd_sc_hd__dfxbp_2
x145 net594 net595 GND GND VCC VCC net596 sky130_fd_sc_hd__dfxtp_1
x146 net597 net598 GND GND VCC VCC net599 sky130_fd_sc_hd__dfxtp_2
x147 net600 net601 GND GND VCC VCC net602 sky130_fd_sc_hd__dfxtp_4
x148 net603 GND GND VCC VCC sky130_fd_sc_hd__diode_2
x149 net604 net605 GND GND VCC VCC net606 sky130_fd_sc_hd__dlclkp_1
x150 net607 net608 GND GND VCC VCC net609 sky130_fd_sc_hd__dlclkp_2
x151 net610 net611 GND GND VCC VCC net612 sky130_fd_sc_hd__dlclkp_4
x152 net613 net614 net615 GND GND VCC VCC net616 net617 sky130_fd_sc_hd__dlrbn_1
x153 net618 net619 net620 GND GND VCC VCC net621 net622 sky130_fd_sc_hd__dlrbn_2
x154 net623 net624 net625 GND GND VCC VCC net626 net627 sky130_fd_sc_hd__dlrbp_1
x155 net628 net629 net630 GND GND VCC VCC net631 net632 sky130_fd_sc_hd__dlrbp_2
x156 net633 net634 net635 GND GND VCC VCC net636 sky130_fd_sc_hd__dlrtn_1
x157 net637 net638 net639 GND GND VCC VCC net640 sky130_fd_sc_hd__dlrtn_2
x158 net641 net642 net643 GND GND VCC VCC net644 sky130_fd_sc_hd__dlrtn_4
x159 net645 net646 net647 GND GND VCC VCC net648 sky130_fd_sc_hd__dlrtp_1
x160 net649 net650 net651 GND GND VCC VCC net652 sky130_fd_sc_hd__dlrtp_2
x161 net653 net654 net655 GND GND VCC VCC net656 sky130_fd_sc_hd__dlrtp_4
x162 net657 net658 GND GND VCC VCC net659 net660 sky130_fd_sc_hd__dlxbn_1
x163 net661 net662 GND GND VCC VCC net663 net664 sky130_fd_sc_hd__dlxbn_2
x164 net665 net666 GND GND VCC VCC net667 net668 sky130_fd_sc_hd__dlxbp_1
x165 net669 net670 GND GND VCC VCC net671 sky130_fd_sc_hd__dlxtn_1
x166 net672 net673 GND GND VCC VCC net674 sky130_fd_sc_hd__dlxtn_2
x167 net675 net676 GND GND VCC VCC net677 sky130_fd_sc_hd__dlxtn_4
x168 net678 net679 GND GND VCC VCC net680 sky130_fd_sc_hd__dlxtp_1
x169 net681 GND GND VCC VCC net682 sky130_fd_sc_hd__dlygate4sd1_1
x170 net683 GND GND VCC VCC net684 sky130_fd_sc_hd__dlygate4sd2_1
x171 net685 GND GND VCC VCC net686 sky130_fd_sc_hd__dlygate4sd3_1
x172 net687 GND GND VCC VCC net688 sky130_fd_sc_hd__dlymetal6s2s_1
x173 net689 GND GND VCC VCC net690 sky130_fd_sc_hd__dlymetal6s4s_1
x174 net691 GND GND VCC VCC net692 sky130_fd_sc_hd__dlymetal6s6s_1
x175 net693 net694 GND GND VCC VCC net695 sky130_fd_sc_hd__ebufn_1
x176 net696 net697 GND GND VCC VCC net698 sky130_fd_sc_hd__ebufn_2
x177 net699 net700 GND GND VCC VCC net701 sky130_fd_sc_hd__ebufn_4
x178 net702 net703 GND GND VCC VCC net704 sky130_fd_sc_hd__ebufn_8
x179 net705 net706 net707 GND GND VCC VCC net708 net709 sky130_fd_sc_hd__edfxbp_1
x180 net710 net711 net712 GND GND VCC VCC net713 sky130_fd_sc_hd__edfxtp_1
x181 net714 net715 GND GND VCC VCC net716 sky130_fd_sc_hd__einvn_0
x182 net717 net718 GND GND VCC VCC net719 sky130_fd_sc_hd__einvn_1
x183 net720 net721 GND GND VCC VCC net722 sky130_fd_sc_hd__einvn_2
x184 net723 net724 GND GND VCC VCC net725 sky130_fd_sc_hd__einvn_4
x185 net726 net727 GND GND VCC VCC net728 sky130_fd_sc_hd__einvn_8
x186 net729 net730 GND GND VCC VCC net731 sky130_fd_sc_hd__einvp_1
x187 net732 net733 GND GND VCC VCC net734 sky130_fd_sc_hd__einvp_2
x188 net735 net736 GND GND VCC VCC net737 sky130_fd_sc_hd__einvp_4
x189 net738 net739 GND GND VCC VCC net740 sky130_fd_sc_hd__einvp_8
x190 net741 net742 net743 GND GND VCC VCC net744 net745 sky130_fd_sc_hd__fa_1
x191 net746 net747 net748 GND GND VCC VCC net749 net750 sky130_fd_sc_hd__fa_2
x192 net751 net752 net753 GND GND VCC VCC net754 net755 sky130_fd_sc_hd__fa_4
x193 net756 net757 net758 GND GND VCC VCC net759 net760 sky130_fd_sc_hd__fah_1
x194 net761 net762 net763 GND GND VCC VCC net764 net765 sky130_fd_sc_hd__fahcin_1
x195 net766 net767 net768 GND GND VCC VCC net769 net770 sky130_fd_sc_hd__fahcon_1
x196 GND GND VCC VCC sky130_fd_sc_hd__fill_1
x197 GND GND VCC VCC sky130_fd_sc_hd__fill_2
x198 GND GND VCC VCC sky130_fd_sc_hd__fill_4
x199 GND GND VCC VCC sky130_fd_sc_hd__fill_8
x200 net771 net772 GND GND VCC VCC net773 net774 sky130_fd_sc_hd__ha_1
x201 net775 net776 GND GND VCC VCC net777 net778 sky130_fd_sc_hd__ha_2
x202 net779 net780 GND GND VCC VCC net781 net782 sky130_fd_sc_hd__ha_4
x203 net783 GND GND VCC VCC net784 sky130_fd_sc_hd__inv_12
x204 net785 GND GND VCC VCC net786 sky130_fd_sc_hd__inv_16
x205 net787 GND GND VCC VCC net788 sky130_fd_sc_hd__inv_1
x206 net789 GND GND VCC VCC net790 sky130_fd_sc_hd__inv_2
x207 net791 GND GND VCC VCC net792 sky130_fd_sc_hd__inv_4
x208 net793 GND GND VCC VCC net794 sky130_fd_sc_hd__inv_6
x209 net795 GND GND VCC VCC net796 sky130_fd_sc_hd__inv_8
x210 net797 GND GND VCC VCC sky130_fd_sc_hd__lpflow_bleeder_1
x211 net798 net799 GND GND VCC VCC net800 sky130_fd_sc_hd__lpflow_clkbufkapwr_16
x212 net801 net802 GND GND VCC VCC net803 sky130_fd_sc_hd__lpflow_clkbufkapwr_1
x213 net804 net805 GND GND VCC VCC net806 sky130_fd_sc_hd__lpflow_clkbufkapwr_2
x214 net807 net808 GND GND VCC VCC net809 sky130_fd_sc_hd__lpflow_clkbufkapwr_4
x215 net810 net811 GND GND VCC VCC net812 sky130_fd_sc_hd__lpflow_clkbufkapwr_8
x216 net813 net814 GND GND VCC VCC net815 sky130_fd_sc_hd__lpflow_clkinvkapwr_16
x217 net816 net817 GND GND VCC VCC net818 sky130_fd_sc_hd__lpflow_clkinvkapwr_1
x218 net819 net820 GND GND VCC VCC net821 sky130_fd_sc_hd__lpflow_clkinvkapwr_2
x219 net822 net823 GND GND VCC VCC net824 sky130_fd_sc_hd__lpflow_clkinvkapwr_4
x220 net825 net826 GND GND VCC VCC net827 sky130_fd_sc_hd__lpflow_clkinvkapwr_8
x221 net828 GND GND VCC VCC sky130_fd_sc_hd__lpflow_decapkapwr_12
x222 net829 GND GND VCC VCC sky130_fd_sc_hd__lpflow_decapkapwr_3
x223 net830 GND GND VCC VCC sky130_fd_sc_hd__lpflow_decapkapwr_4
x224 net831 GND GND VCC VCC sky130_fd_sc_hd__lpflow_decapkapwr_6
x225 net832 GND GND VCC VCC sky130_fd_sc_hd__lpflow_decapkapwr_8
x226 net833 net834 GND GND VCC VCC net835 sky130_fd_sc_hd__lpflow_inputiso0n_1
x227 net836 net837 GND GND VCC VCC net838 sky130_fd_sc_hd__lpflow_inputiso0p_1
x228 net839 net840 GND GND VCC VCC net841 sky130_fd_sc_hd__lpflow_inputiso1n_1
x229 net842 net843 GND GND VCC VCC net844 sky130_fd_sc_hd__lpflow_inputiso1p_1
x230 net845 net846 GND GND VCC VCC net847 sky130_fd_sc_hd__lpflow_inputisolatch_1
x231 net848 net849 GND GND VCC VCC net850 sky130_fd_sc_hd__lpflow_isobufsrc_16
x232 net851 net852 GND GND VCC VCC net853 sky130_fd_sc_hd__lpflow_isobufsrc_1
x233 net854 net855 GND GND VCC VCC net856 sky130_fd_sc_hd__lpflow_isobufsrc_2
x234 net857 net858 GND GND VCC VCC net859 sky130_fd_sc_hd__lpflow_isobufsrc_4
x235 net860 net861 GND GND VCC VCC net862 sky130_fd_sc_hd__lpflow_isobufsrc_8
x236 net863 net864 net865 GND GND VCC VCC net866 sky130_fd_sc_hd__lpflow_isobufsrckapwr_16
x237 net867 GND VCC net868 VCC net869 sky130_fd_sc_hd__lpflow_lsbuf_lh_hl_isowell_tap_1
x238 net870 GND VCC net871 VCC net872 sky130_fd_sc_hd__lpflow_lsbuf_lh_hl_isowell_tap_2
x239 net873 GND VCC net874 VCC net875 sky130_fd_sc_hd__lpflow_lsbuf_lh_hl_isowell_tap_4
x240 net876 net877 GND GND VCC VCC net878 sky130_fd_sc_hd__lpflow_lsbuf_lh_isowell_4
x241 net879 net880 GND VCC VCC net881 sky130_fd_sc_hd__lpflow_lsbuf_lh_isowell_tap_1
x242 net882 net883 GND VCC VCC net884 sky130_fd_sc_hd__lpflow_lsbuf_lh_isowell_tap_2
x243 net885 net886 GND VCC VCC net887 sky130_fd_sc_hd__lpflow_lsbuf_lh_isowell_tap_4
x244 GND GND VCC VCC net888 sky130_fd_sc_hd__macro_sparecell
x245 net889 net890 net891 GND GND VCC VCC net892 sky130_fd_sc_hd__maj3_1
x246 net893 net894 net895 GND GND VCC VCC net896 sky130_fd_sc_hd__maj3_2
x247 net897 net898 net899 GND GND VCC VCC net900 sky130_fd_sc_hd__maj3_4
x248 net901 net902 net903 GND GND VCC VCC net904 sky130_fd_sc_hd__mux2_1
x249 net905 net906 net907 GND GND VCC VCC net908 sky130_fd_sc_hd__mux2_2
x250 net909 net910 net911 GND GND VCC VCC net912 sky130_fd_sc_hd__mux2_4
x251 net913 net914 net915 GND GND VCC VCC net916 sky130_fd_sc_hd__mux2_8
x252 net917 net918 net919 GND GND VCC VCC net920 sky130_fd_sc_hd__mux2i_1
x253 net921 net922 net923 GND GND VCC VCC net924 sky130_fd_sc_hd__mux2i_2
x254 net925 net926 net927 GND GND VCC VCC net928 sky130_fd_sc_hd__mux2i_4
x255 net929 net930 net931 net932 net933 net934 GND GND VCC VCC net935 sky130_fd_sc_hd__mux4_1
x256 net936 net937 net938 net939 net940 net941 GND GND VCC VCC net942 sky130_fd_sc_hd__mux4_2
x257 net943 net944 net945 net946 net947 net948 GND GND VCC VCC net949 sky130_fd_sc_hd__mux4_4
x258 net950 net951 GND GND VCC VCC net952 sky130_fd_sc_hd__nand2_1
x259 net953 net954 GND GND VCC VCC net955 sky130_fd_sc_hd__nand2_2
x260 net956 net957 GND GND VCC VCC net958 sky130_fd_sc_hd__nand2_4
x261 net959 net960 GND GND VCC VCC net961 sky130_fd_sc_hd__nand2_8
x262 net962 net963 GND GND VCC VCC net964 sky130_fd_sc_hd__nand2b_1
x263 net965 net966 GND GND VCC VCC net967 sky130_fd_sc_hd__nand2b_2
x264 net968 net969 GND GND VCC VCC net970 sky130_fd_sc_hd__nand2b_4
x265 net971 net972 net973 GND GND VCC VCC net974 sky130_fd_sc_hd__nand3_1
x266 net975 net976 net977 GND GND VCC VCC net978 sky130_fd_sc_hd__nand3_2
x267 net979 net980 net981 GND GND VCC VCC net982 sky130_fd_sc_hd__nand3_4
x268 net983 net984 net985 GND GND VCC VCC net986 sky130_fd_sc_hd__nand3b_1
x269 net987 net988 net989 GND GND VCC VCC net990 sky130_fd_sc_hd__nand3b_2
x270 net991 net992 net993 GND GND VCC VCC net994 sky130_fd_sc_hd__nand3b_4
x271 net995 net996 net997 net998 GND GND VCC VCC net999 sky130_fd_sc_hd__nand4_1
x272 net1000 net1001 net1002 net1003 GND GND VCC VCC net1004 sky130_fd_sc_hd__nand4_2
x273 net1005 net1006 net1007 net1008 GND GND VCC VCC net1009 sky130_fd_sc_hd__nand4_4
x274 net1011 net1012 net1013 GND GND VCC VCC net1014 sky130_fd_sc_hd__nand4b_1
x275 net1016 net1017 net1018 GND GND VCC VCC net1019 sky130_fd_sc_hd__nand4b_2
x276 net1021 net1022 net1023 GND GND VCC VCC net1024 sky130_fd_sc_hd__nand4b_4
x277 net1027 net1028 GND GND VCC VCC net1029 sky130_fd_sc_hd__nand4bb_1
x278 net1032 net1033 GND GND VCC VCC net1034 sky130_fd_sc_hd__nand4bb_2
x279 net1037 net1038 GND GND VCC VCC net1039 sky130_fd_sc_hd__nand4bb_4
x280 net1040 net1041 GND GND VCC VCC net1042 sky130_fd_sc_hd__nor2_1
x281 net1043 net1044 GND GND VCC VCC net1045 sky130_fd_sc_hd__nor2_2
x282 net1046 net1047 GND GND VCC VCC net1048 sky130_fd_sc_hd__nor2_4
x283 net1049 net1050 GND GND VCC VCC net1051 sky130_fd_sc_hd__nor2_8
x284 net1052 net1053 GND GND VCC VCC net1054 sky130_fd_sc_hd__nor2b_1
x285 net1055 net1056 GND GND VCC VCC net1057 sky130_fd_sc_hd__nor2b_2
x286 net1058 net1059 GND GND VCC VCC net1060 sky130_fd_sc_hd__nor2b_4
x287 net1061 net1062 net1063 GND GND VCC VCC net1064 sky130_fd_sc_hd__nor3_1
x288 net1065 net1066 net1067 GND GND VCC VCC net1068 sky130_fd_sc_hd__nor3_2
x289 net1069 net1070 net1071 GND GND VCC VCC net1072 sky130_fd_sc_hd__nor3_4
x290 net1073 net1074 net1075 GND GND VCC VCC net1076 sky130_fd_sc_hd__nor3b_1
x291 net1077 net1078 net1079 GND GND VCC VCC net1080 sky130_fd_sc_hd__nor3b_2
x292 net1081 net1082 net1083 GND GND VCC VCC net1084 sky130_fd_sc_hd__nor3b_4
x293 net1085 net1086 net1087 net1088 GND GND VCC VCC net1089 sky130_fd_sc_hd__nor4_1
x294 net1090 net1091 net1092 net1093 GND GND VCC VCC net1094 sky130_fd_sc_hd__nor4_2
x295 net1095 net1096 net1097 net1098 GND GND VCC VCC net1099 sky130_fd_sc_hd__nor4_4
x296 net1100 net1101 net1102 net1103 GND GND VCC VCC net1104 sky130_fd_sc_hd__nor4b_1
x297 net1105 net1106 net1107 net1108 GND GND VCC VCC net1109 sky130_fd_sc_hd__nor4b_2
x298 net1110 net1111 net1112 net1113 GND GND VCC VCC net1114 sky130_fd_sc_hd__nor4b_4
x299 net1115 net1116 net1117 net1118 GND GND VCC VCC net1119 sky130_fd_sc_hd__nor4bb_1
x300 net1120 net1121 net1122 net1123 GND GND VCC VCC net1124 sky130_fd_sc_hd__nor4bb_2
x301 net1125 net1126 net1127 net1128 GND GND VCC VCC net1129 sky130_fd_sc_hd__nor4bb_4
x302 net1130 net1131 net1132 net1133 net1134 GND GND VCC VCC net1135 sky130_fd_sc_hd__o2111a_1
x303 net1136 net1137 net1138 net1139 net1140 GND GND VCC VCC net1141 sky130_fd_sc_hd__o2111a_2
x304 net1142 net1143 net1144 net1145 net1146 GND GND VCC VCC net1147 sky130_fd_sc_hd__o2111a_4
x305 net1148 net1149 net1150 net1151 net1152 GND GND VCC VCC net1153 sky130_fd_sc_hd__o2111ai_1
x306 net1154 net1155 net1156 net1157 net1158 GND GND VCC VCC net1159 sky130_fd_sc_hd__o2111ai_2
x307 net1160 net1161 net1162 net1163 net1164 GND GND VCC VCC net1165 sky130_fd_sc_hd__o2111ai_4
x308 net1166 net1167 net1168 net1169 GND GND VCC VCC net1170 sky130_fd_sc_hd__o211a_1
x309 net1171 net1172 net1173 net1174 GND GND VCC VCC net1175 sky130_fd_sc_hd__o211a_2
x310 net1176 net1177 net1178 net1179 GND GND VCC VCC net1180 sky130_fd_sc_hd__o211a_4
x311 net1181 net1182 net1183 net1184 GND GND VCC VCC net1185 sky130_fd_sc_hd__o211ai_1
x312 net1186 net1187 net1188 net1189 GND GND VCC VCC net1190 sky130_fd_sc_hd__o211ai_2
x313 net1191 net1192 net1193 net1194 GND GND VCC VCC net1195 sky130_fd_sc_hd__o211ai_4
x314 net1196 net1197 net1198 GND GND VCC VCC net1199 sky130_fd_sc_hd__o21a_1
x315 net1200 net1201 net1202 GND GND VCC VCC net1203 sky130_fd_sc_hd__o21a_2
x316 net1204 net1205 net1206 GND GND VCC VCC net1207 sky130_fd_sc_hd__o21a_4
x317 net1208 net1209 net1210 GND GND VCC VCC net1211 sky130_fd_sc_hd__o21ai_0
x318 net1212 net1213 net1214 GND GND VCC VCC net1215 sky130_fd_sc_hd__o21ai_1
x319 net1216 net1217 net1218 GND GND VCC VCC net1219 sky130_fd_sc_hd__o21ai_2
x320 net1220 net1221 net1222 GND GND VCC VCC net1223 sky130_fd_sc_hd__o21ai_4
x321 net1224 net1225 net1226 GND GND VCC VCC net1227 sky130_fd_sc_hd__o21ba_1
x322 net1228 net1229 net1230 GND GND VCC VCC net1231 sky130_fd_sc_hd__o21ba_2
x323 net1232 net1233 net1234 GND GND VCC VCC net1235 sky130_fd_sc_hd__o21ba_4
x324 net1236 net1237 net1238 GND GND VCC VCC net1239 sky130_fd_sc_hd__o21bai_1
x325 net1240 net1241 net1242 GND GND VCC VCC net1243 sky130_fd_sc_hd__o21bai_2
x326 net1244 net1245 net1246 GND GND VCC VCC net1247 sky130_fd_sc_hd__o21bai_4
x327 net1248 net1249 net1250 net1251 net1252 GND GND VCC VCC net1253 sky130_fd_sc_hd__o221a_1
x328 net1254 net1255 net1256 net1257 net1258 GND GND VCC VCC net1259 sky130_fd_sc_hd__o221a_2
x329 net1260 net1261 net1262 net1263 net1264 GND GND VCC VCC net1265 sky130_fd_sc_hd__o221a_4
x330 net1266 net1267 net1268 net1269 net1270 GND GND VCC VCC net1271 sky130_fd_sc_hd__o221ai_1
x331 net1272 net1273 net1274 net1275 net1276 GND GND VCC VCC net1277 sky130_fd_sc_hd__o221ai_2
x332 net1278 net1279 net1280 net1281 net1282 GND GND VCC VCC net1283 sky130_fd_sc_hd__o221ai_4
x333 net1284 net1285 net1286 net1287 GND GND VCC VCC net1288 sky130_fd_sc_hd__o22a_1
x334 net1289 net1290 net1291 net1292 GND GND VCC VCC net1293 sky130_fd_sc_hd__o22a_2
x335 net1294 net1295 net1296 net1297 GND GND VCC VCC net1298 sky130_fd_sc_hd__o22a_4
x336 net1299 net1300 net1301 net1302 GND GND VCC VCC net1303 sky130_fd_sc_hd__o22ai_1
x337 net1304 net1305 net1306 net1307 GND GND VCC VCC net1308 sky130_fd_sc_hd__o22ai_2
x338 net1309 net1310 net1311 net1312 GND GND VCC VCC net1313 sky130_fd_sc_hd__o22ai_4
x339 net1314 net1315 net1316 net1317 GND GND VCC VCC net1318 sky130_fd_sc_hd__o2bb2a_1
x340 net1319 net1320 net1321 net1322 GND GND VCC VCC net1323 sky130_fd_sc_hd__o2bb2a_2
x341 net1324 net1325 net1326 net1327 GND GND VCC VCC net1328 sky130_fd_sc_hd__o2bb2a_4
x342 net1329 net1330 net1331 net1332 GND GND VCC VCC net1333 sky130_fd_sc_hd__o2bb2ai_1
x343 net1334 net1335 net1336 net1337 GND GND VCC VCC net1338 sky130_fd_sc_hd__o2bb2ai_2
x344 net1339 net1340 net1341 net1342 GND GND VCC VCC net1343 sky130_fd_sc_hd__o2bb2ai_4
x345 net1344 net1345 net1346 net1347 net1348 GND GND VCC VCC net1349 sky130_fd_sc_hd__o311a_1
x346 net1350 net1351 net1352 net1353 net1354 GND GND VCC VCC net1355 sky130_fd_sc_hd__o311a_2
x347 net1356 net1357 net1358 net1359 net1360 GND GND VCC VCC net1361 sky130_fd_sc_hd__o311a_4
x348 net1362 net1363 net1364 net1365 net1366 GND GND VCC VCC net1367 sky130_fd_sc_hd__o311ai_0
x349 net1368 net1369 net1370 net1371 net1372 GND GND VCC VCC net1373 sky130_fd_sc_hd__o311ai_1
x350 net1374 net1375 net1376 net1377 net1378 GND GND VCC VCC net1379 sky130_fd_sc_hd__o311ai_2
x351 net1380 net1381 net1382 net1383 net1384 GND GND VCC VCC net1385 sky130_fd_sc_hd__o311ai_4
x352 net1386 net1387 net1388 net1389 GND GND VCC VCC net1390 sky130_fd_sc_hd__o31a_1
x353 net1391 net1392 net1393 net1394 GND GND VCC VCC net1395 sky130_fd_sc_hd__o31a_2
x354 net1396 net1397 net1398 net1399 GND GND VCC VCC net1400 sky130_fd_sc_hd__o31a_4
x355 net1401 net1402 net1403 net1404 GND GND VCC VCC net1405 sky130_fd_sc_hd__o31ai_1
x356 net1406 net1407 net1408 net1409 GND GND VCC VCC net1410 sky130_fd_sc_hd__o31ai_2
x357 net1411 net1412 net1413 net1414 GND GND VCC VCC net1415 sky130_fd_sc_hd__o31ai_4
x358 net1416 net1417 net1418 net1419 net1420 GND GND VCC VCC net1421 sky130_fd_sc_hd__o32a_1
x359 net1422 net1423 net1424 net1425 net1426 GND GND VCC VCC net1427 sky130_fd_sc_hd__o32a_2
x360 net1428 net1429 net1430 net1431 net1432 GND GND VCC VCC net1433 sky130_fd_sc_hd__o32a_4
x361 net1434 net1435 net1436 net1437 net1438 GND GND VCC VCC net1439 sky130_fd_sc_hd__o32ai_1
x362 net1440 net1441 net1442 net1443 net1444 GND GND VCC VCC net1445 sky130_fd_sc_hd__o32ai_2
x363 net1446 net1447 net1448 net1449 net1450 GND GND VCC VCC net1451 sky130_fd_sc_hd__o32ai_4
x364 net1452 net1453 net1454 net1455 net1456 GND GND VCC VCC net1457 sky130_fd_sc_hd__o41a_1
x365 net1458 net1459 net1460 net1461 net1462 GND GND VCC VCC net1463 sky130_fd_sc_hd__o41a_2
x366 net1464 net1465 net1466 net1467 net1468 GND GND VCC VCC net1469 sky130_fd_sc_hd__o41a_4
x367 net1470 net1471 net1472 net1473 net1474 GND GND VCC VCC net1475 sky130_fd_sc_hd__o41ai_1
x368 net1476 net1477 net1478 net1479 net1480 GND GND VCC VCC net1481 sky130_fd_sc_hd__o41ai_2
x369 net1482 net1483 net1484 net1485 net1486 GND GND VCC VCC net1487 sky130_fd_sc_hd__o41ai_4
x370 net1488 net1489 GND GND VCC VCC net1490 sky130_fd_sc_hd__or2_0
x371 net1491 net1492 GND GND VCC VCC net1493 sky130_fd_sc_hd__or2_1
x372 net1494 net1495 GND GND VCC VCC net1496 sky130_fd_sc_hd__or2_2
x373 net1497 net1498 GND GND VCC VCC net1499 sky130_fd_sc_hd__or2_4
x374 net1500 net1501 GND GND VCC VCC net1502 sky130_fd_sc_hd__or2b_1
x375 net1503 net1504 GND GND VCC VCC net1505 sky130_fd_sc_hd__or2b_2
x376 net1506 net1507 GND GND VCC VCC net1508 sky130_fd_sc_hd__or2b_4
x377 net1509 net1510 net1511 GND GND VCC VCC net1512 sky130_fd_sc_hd__or3_1
x378 net1513 net1514 net1515 GND GND VCC VCC net1516 sky130_fd_sc_hd__or3_2
x379 net1517 net1518 net1519 GND GND VCC VCC net1520 sky130_fd_sc_hd__or3_4
x380 net1521 net1522 net1523 GND GND VCC VCC net1524 sky130_fd_sc_hd__or3b_1
x381 net1525 net1526 net1527 GND GND VCC VCC net1528 sky130_fd_sc_hd__or3b_2
x382 net1529 net1530 net1531 GND GND VCC VCC net1532 sky130_fd_sc_hd__or3b_4
x383 net1533 net1534 net1535 net1536 GND GND VCC VCC net1537 sky130_fd_sc_hd__or4_1
x384 net1538 net1539 net1540 net1541 GND GND VCC VCC net1542 sky130_fd_sc_hd__or4_2
x385 net1543 net1544 net1545 net1546 GND GND VCC VCC net1547 sky130_fd_sc_hd__or4_4
x386 net1548 net1549 net1550 net1551 GND GND VCC VCC net1552 sky130_fd_sc_hd__or4b_1
x387 net1553 net1554 net1555 net1556 GND GND VCC VCC net1557 sky130_fd_sc_hd__or4b_2
x388 net1558 net1559 net1560 net1561 GND GND VCC VCC net1562 sky130_fd_sc_hd__or4b_4
x389 net1563 net1564 net1565 net1566 GND GND VCC VCC net1567 sky130_fd_sc_hd__or4bb_1
x390 net1568 net1569 net1570 net1571 GND GND VCC VCC net1572 sky130_fd_sc_hd__or4bb_2
x391 net1573 net1574 net1575 net1576 GND GND VCC VCC net1577 sky130_fd_sc_hd__or4bb_4
x392 net1578 GND GND VCC VCC net1579 sky130_fd_sc_hd__probec_p_8
x393 net1580 GND GND VCC VCC net1581 sky130_fd_sc_hd__probe_p_8
x394 net1582 net1583 net1584 net1585 net1586 net1587 GND GND VCC VCC net1588 net1589 sky130_fd_sc_hd__sdfbbn_1
x395 net1590 net1591 net1592 net1593 net1594 net1595 GND GND VCC VCC net1596 net1597 sky130_fd_sc_hd__sdfbbn_2
x396 net1598 net1599 net1600 net1601 net1602 net1603 GND GND VCC VCC net1604 net1605 sky130_fd_sc_hd__sdfbbp_1
x397 net1606 net1607 net1608 net1609 net1610 GND GND VCC VCC net1611 net1612 sky130_fd_sc_hd__sdfrbp_1
x398 net1613 net1614 net1615 net1616 net1617 GND GND VCC VCC net1618 net1619 sky130_fd_sc_hd__sdfrbp_2
x399 net1620 net1621 net1622 net1623 net1624 GND GND VCC VCC net1625 sky130_fd_sc_hd__sdfrtn_1
x400 net1626 net1627 net1628 net1629 net1630 GND GND VCC VCC net1631 sky130_fd_sc_hd__sdfrtp_1
x401 net1632 net1633 net1634 net1635 net1636 GND GND VCC VCC net1637 sky130_fd_sc_hd__sdfrtp_2
x402 net1638 net1639 net1640 net1641 net1642 GND GND VCC VCC net1643 sky130_fd_sc_hd__sdfrtp_4
x403 net1644 net1645 net1646 net1647 net1648 GND GND VCC VCC net1649 net1650 sky130_fd_sc_hd__sdfsbp_1
x404 net1651 net1652 net1653 net1654 net1655 GND GND VCC VCC net1656 net1657 sky130_fd_sc_hd__sdfsbp_2
x405 net1658 net1659 net1660 net1661 net1662 GND GND VCC VCC net1663 sky130_fd_sc_hd__sdfstp_1
x406 net1664 net1665 net1666 net1667 net1668 GND GND VCC VCC net1669 sky130_fd_sc_hd__sdfstp_2
x407 net1670 net1671 net1672 net1673 net1674 GND GND VCC VCC net1675 sky130_fd_sc_hd__sdfstp_4
x408 net1676 net1677 net1678 net1679 GND GND VCC VCC net1680 net1681 sky130_fd_sc_hd__sdfxbp_1
x409 net1682 net1683 net1684 net1685 GND GND VCC VCC net1686 net1687 sky130_fd_sc_hd__sdfxbp_2
x410 net1688 net1689 net1690 net1691 GND GND VCC VCC net1692 sky130_fd_sc_hd__sdfxtp_1
x411 net1693 net1694 net1695 net1696 GND GND VCC VCC net1697 sky130_fd_sc_hd__sdfxtp_2
x412 net1698 net1699 net1700 net1701 GND GND VCC VCC net1702 sky130_fd_sc_hd__sdfxtp_4
x413 net1703 net1704 net1705 GND GND VCC VCC net1706 sky130_fd_sc_hd__sdlclkp_1
x414 net1707 net1708 net1709 GND GND VCC VCC net1710 sky130_fd_sc_hd__sdlclkp_2
x415 net1711 net1712 net1713 GND GND VCC VCC net1714 sky130_fd_sc_hd__sdlclkp_4
x416 net1715 net1716 net1717 net1718 net1719 GND GND VCC VCC net1720 net1721 sky130_fd_sc_hd__sedfxbp_1
x417 net1722 net1723 net1724 net1725 net1726 GND GND VCC VCC net1727 net1728 sky130_fd_sc_hd__sedfxbp_2
x418 net1729 net1730 net1731 net1732 net1733 GND GND VCC VCC net1734 sky130_fd_sc_hd__sedfxtp_1
x419 net1735 net1736 net1737 net1738 net1739 GND GND VCC VCC net1740 sky130_fd_sc_hd__sedfxtp_2
x420 net1741 net1742 net1743 net1744 net1745 GND GND VCC VCC net1746 sky130_fd_sc_hd__sedfxtp_4
x421 GND GND VCC VCC sky130_fd_sc_hd__tap_1
x422 GND GND VCC VCC sky130_fd_sc_hd__tap_2
x423 GND VCC VCC sky130_fd_sc_hd__tapvgnd_1
x424 GND VCC VCC sky130_fd_sc_hd__tapvgnd2_1
x425 GND VCC sky130_fd_sc_hd__tapvpwrvgnd_1
x426 net1747 net1748 GND GND VCC VCC net1749 sky130_fd_sc_hd__xnor2_1
x427 net1750 net1751 GND GND VCC VCC net1752 sky130_fd_sc_hd__xnor2_2
x428 net1753 net1754 GND GND VCC VCC net1755 sky130_fd_sc_hd__xnor2_4
x429 net1756 net1757 net1759 GND GND VCC VCC net1758 sky130_fd_sc_hd__xnor3_1
x430 net1760 net1761 net1763 GND GND VCC VCC net1762 sky130_fd_sc_hd__xnor3_2
x431 net1764 net1765 net1767 GND GND VCC VCC net1766 sky130_fd_sc_hd__xnor3_4
x432 net1768 net1769 GND GND VCC VCC net1770 sky130_fd_sc_hd__xor2_1
x433 net1771 net1772 GND GND VCC VCC net1773 sky130_fd_sc_hd__xor2_2
x434 net1774 net1775 GND GND VCC VCC net1776 sky130_fd_sc_hd__xor2_4
x435 net1777 net1778 net1780 GND GND VCC VCC net1779 sky130_fd_sc_hd__xor3_1
x436 net1781 net1782 net1784 GND GND VCC VCC net1783 sky130_fd_sc_hd__xor3_2
x437 net1785 net1786 net1788 GND GND VCC VCC net1787 sky130_fd_sc_hd__xor3_4
.ends

* expanding   symbol:  sky130_tests/test_varactor.sym # of pins=0
** sym_path: /pdk/sky130A/libs.tech/xschem/sky130_tests/test_varactor.sym
** sch_path: /pdk/sky130A/libs.tech/xschem/sky130_tests/test_varactor.sch
.subckt test_varactor
I1 0 G1 pwl 0 0 1p 100n
R1 G1 REF 100G
I2 0 G pwl 0 0 1p 100n
R2 G REF 100G
V1 REF 0 -2.1
XC4 G1 0 0 sky130_fd_pr__cap_var_lvt W=5 L=5 VM=1
XM2 0 G 0 0 sky130_fd_pr__pfet_01v8 L=5 W=5 nf=1 ad=1.45 as=1.45 pd=10.58 ps=10.58 nrd=0.058 nrs=0.058 sa=0 sb=0 sd=0 mult=1
I3 0 G2 pwl 0 0 1p 100n
R3 G2 REF 100G
XC1 G2 net1 0 sky130_fd_pr__cap_var_lvt W=5 L=5 VM=1
V3 net1 0 1.8
.ends

* expanding   symbol:  sky130_tests/test_vpp_cap.sym # of pins=0
** sym_path: /pdk/sky130A/libs.tech/xschem/sky130_tests/test_vpp_cap.sym
** sch_path: /pdk/sky130A/libs.tech/xschem/sky130_tests/test_vpp_cap.sch
.subckt test_vpp_cap
I1 0 net1 pwl 0 0 1000n 0 1010n 100n
R1 G1 REF 1G
I3 0 net3 pwl 0 0 1000n 0 1010n 100n
R3 G3 REF 1G
C2 G2 0 137.45f
V1 REF 0 0
XC1 G1 0 0 0 sky130_fd_pr__cap_vpp_11p5x11p7_l1m1m2m3m4_shieldm5 mult=1
I2 0 net2 pwl 0 0 1000n 0 1010n 100n
R2 G2 REF 1G
XC4 G4 0 0 0 sky130_fd_pr__cap_vpp_06p8x06p1_m1m2m3_shieldl1m4 mult=1
I4 0 net4 pwl 0 0 1000n 0 1010n 100n
R4 G4 REF 1G
C3 G3 0 42.11f
Vc1 net1 G1 0
.save i(vc1)
Vc2 net2 G2 0
.save i(vc2)
Vc3 net3 G3 0
.save i(vc3)
Vc4 net4 G4 0
.save i(vc4)
.ends

* expanding   symbol:  mips_cpu/tb.sym # of pins=0
** sym_path: /pdk/sky130A/libs.tech/xschem/mips_cpu/tb.sym
** sch_path: /pdk/sky130A/libs.tech/xschem/mips_cpu/tb.sch
.subckt tb
xuut clock reset top
* noconn clock
* noconn reset
.ends

* expanding   symbol:  sky130_tests/test_mim_cap.sym # of pins=0
** sym_path: /pdk/sky130A/libs.tech/xschem/sky130_tests/test_mim_cap.sym
** sch_path: /pdk/sky130A/libs.tech/xschem/sky130_tests/test_mim_cap.sch
.subckt test_mim_cap
I1 0 G pwl 0 0 1000n 0 1010n 100n
R1 G REF 1G
I3 0 G2 pwl 0 0 1000n 0 1010n 100n
R3 G2 REF 1G
C1 G2 0 0.205p m=2
V1 REF 0 -2
XC2 G 0 sky130_fd_pr__cap_mim_m3_2 W=10 L=10 MF=2 m=2
**** begin user architecture code

**** end user architecture code
**** begin user architecture code

.control
save all
tran 10n 6u
plot g g2
write test_mim_cap.raw
.endc

**** end user architecture code
.ends

* expanding   symbol:  sky130_tests/LACG.sym # of pins=0
** sym_path: /pdk/sky130A/libs.tech/xschem/sky130_tests/LACG.sym
** sch_path: /pdk/sky130A/libs.tech/xschem/sky130_tests/LACG.sch
.subckt LACG
x1 net1 Q1A GND GND VCC VCC net2 sky130_fd_sc_hd__xor2_1
x2 net1 net3 GND GND VCC VCC Q1A sky130_fd_sc_hd__dlxtp_1
x3 net2 clk_g GND GND VCC VCC X1A sky130_fd_sc_hd__dlxtn_1
x4 V1 clk_g GND GND VCC VCC net1 sky130_fd_sc_hd__dlxtn_1
x5 clk_g net2 GND GND VCC VCC net3 sky130_fd_sc_hd__and2_1
V1 V1 GND pwl 0 0 100n 0 101n 1.8 150n 1.8 151n 0 200n 0 201n 1.8 231n 1.8
x6 net4 Q2A GND GND VCC VCC net5 sky130_fd_sc_hd__xor2_1
x7 net4 net6 GND GND VCC VCC Q2A sky130_fd_sc_hd__dlxtp_1
x8 net5 clk_g GND GND VCC VCC X2A sky130_fd_sc_hd__dlxtn_1
x9 V2 clk_g GND GND VCC VCC net4 sky130_fd_sc_hd__dlxtn_1
x10 clk_g net5 GND GND VCC VCC net6 sky130_fd_sc_hd__and2_1
x11 net7 Q3A GND GND VCC VCC net8 sky130_fd_sc_hd__xor2_1
x12 net7 net9 GND GND VCC VCC Q3A sky130_fd_sc_hd__dlxtp_1
x13 net8 clk_g GND GND VCC VCC X3A sky130_fd_sc_hd__dlxtn_1
x14 V3 clk_g GND GND VCC VCC net7 sky130_fd_sc_hd__dlxtn_1
x15 clk_g net8 GND GND VCC VCC net9 sky130_fd_sc_hd__and2_1
V2 V2 GND pwl 0 0 100n 0 102n 1.8 200n 1.8 202n 0
V3 V3 GND pwl 0 0 130n 0 131n 1.8 170n 1.8 171n 0
x17 x17A_C Q_C GND GND VCC VCC x17X_C sky130_fd_sc_hd__xor2_1
x18 x17A_C x21X_C GND GND VCC VCC Q_C sky130_fd_sc_hd__dlxtp_1
x19 x17X_C clk GND GND VCC VCC XC sky130_fd_sc_hd__dlxtn_1
x20 D_C x22X_C GND GND VCC VCC x17A_C sky130_fd_sc_hd__dlxtn_1
x21 clk x17X_C GND GND VCC VCC x21X_C sky130_fd_sc_hd__and2_1
x22 clk XCB GND GND VCC VCC x22X_C sky130_fd_sc_hd__and2_1
x23 XC GND GND VCC VCC XCB sky130_fd_sc_hd__inv_1
x24 D_C Q_C clk GND GND VCC VCC clk_g sky130_fd_sc_hd__and3_1
x25 net10 Q1B GND GND VCC VCC net11 sky130_fd_sc_hd__xor2_1
x26 net10 net12 GND GND VCC VCC Q1B sky130_fd_sc_hd__dlxtp_1
x27 net11 clk_g GND GND VCC VCC X1B sky130_fd_sc_hd__dlxtn_1
x28 D_B clk_g GND GND VCC VCC net10 sky130_fd_sc_hd__dlxtn_1
x29 clk_g net11 GND GND VCC VCC net12 sky130_fd_sc_hd__and2_1
C1 Q1B GND 0.05p
C2 X1B GND 0.05p
V4 clk GND PULSE 0 1.8 32n 1n 1n 4n 10n
**** begin user architecture code

.control
tran 0.1n 300n
plot clk clk_g+2 V1+4 V2+6 V3+8
write LACG.raw
*plot clk clk_g+2 XC+4 Q_C+6 D_C+8 x22X_C+10 x17X_C+12 x21X_C+14 x17A_C+16
.endc

**** end user architecture code
V5 VCC GND 1.8
x16 X1A X2A X3A GND GND VCC VCC D_C sky130_fd_sc_hd__or3_1
x30 Q1A Q2A Q3A GND GND VCC VCC D_B sky130_fd_sc_hd__and3_1
.ends

* expanding   symbol:  sky130_tests/test_ff.sym # of pins=0
** sym_path: /pdk/sky130A/libs.tech/xschem/sky130_tests/test_ff.sym
** sch_path: /pdk/sky130A/libs.tech/xschem/sky130_tests/test_ff.sch
.subckt test_ff
x17 net9 CLK GND GND VDD VDD net8 sky130_fd_sc_hd__and2_1
x16 D net8 RESETB GND GND VDD VDD Q3 sky130_fd_sc_hd__dlrtp_1
x21 net18 net19 VDD GND lvtnot W_N=0.6 L_N=0.8 W_P=0.6 L_P=0.4
x22 net19 net11 VDD GND lvtnot W_N=0.6 L_N=0.8 W_P=0.6 L_P=0.4
x15 net11 GND GND VDD VDD net9 sky130_fd_sc_hd__inv_1
x20 CLK GND GND VDD VDD net10 sky130_fd_sc_hd__inv_1
x18 net8 D RESETB GND GND VDD VDD net12 sky130_fd_sc_hd__dfrtp_1
x23 net10 net18 VDD GND lvtnot W_N=0.6 L_N=0.8 W_P=0.6 L_P=0.4
V1 D GND pulse 0 1.8 15n .1n .1n 19.9n 40n
V2 CLK GND pulse 0 1.8 10n .1n .1n 9.9n 20n
V3 VDD GND 1.8
x5 net2 net4 GND GND VDD VDD net5 sky130_fd_sc_hd__nand2_1
x6 net5 CLK RESETB GND GND VDD VDD net4 sky130_fd_sc_hd__nand3_1
x7 net4 CLK net2 GND GND VDD VDD net3 sky130_fd_sc_hd__nand3_1
x8 net3 D RESETB GND GND VDD VDD net2 sky130_fd_sc_hd__nand3_1
x9 Q1 net3 RESETB GND GND VDD VDD QN1 sky130_fd_sc_hd__nand3_1
x10 net4 QN1 GND GND VDD VDD Q1 sky130_fd_sc_hd__nand2_1
V4 RESETB GND pwl 0 0 10n 0 11n 1.8
x11 Q2 D GND GND VDD VDD net7 sky130_fd_sc_hd__xor2_1
x13 D net6 RESETB GND GND VDD VDD Q2 sky130_fd_sc_hd__dlrtn_1
x12 net7 CLK GND GND VDD VDD net6 sky130_fd_sc_hd__nand2_1
x3 D DN VDD GND lvtnot W_N=1 L_N=0.15 W_P=2 L_P=0.35
x1 D net1 DN QI QIN srlatch
x2 QI CLK QIN Q QN srlatch
x4 CLK net1 VDD GND lvtnot W_N=1 L_N=0.15 W_P=2 L_P=0.35
x14 CLK D RESETB GND GND VDD VDD net13 net14 sky130_fd_sc_hd__dfrbp_1
x19 CLK net15 VDD GND lvtnot W_N=0.6 L_N=0.8 W_P=0.6 L_P=0.4
x24 net15 net16 VDD GND lvtnot W_N=0.6 L_N=0.8 W_P=0.6 L_P=0.4
x25 CLK D GND GND VDD VDD net17 sky130_fd_sc_hd__dfxtp_1
x26 D CLK RESETB GND GND VDD VDD Q4 Q4B sky130_fd_sc_hd__dlrbp_1
.ends

* expanding   symbol:  sky130_tests/test_analog.sym # of pins=0
** sym_path: /pdk/sky130A/libs.tech/xschem/sky130_tests/test_analog.sym
** sch_path: /pdk/sky130A/libs.tech/xschem/sky130_tests/test_analog.sch
.subckt test_analog
x1 OUT OUT IN BIAS n_diffamp
x2 OUT2 OUT2 IN2 BIAS2 n_diffamp
V1 IN GND 1.2
V2 BIAS GND 1.1
V3 VDD GND 1.8
V4 IN2 GND 1.0
V5 BIAS2 GND 1.0
XR1 GND OUT2 GND sky130_fd_pr__res_xhigh_po_0p35 L=50 mult=1
XR2 GND OUT GND sky130_fd_pr__res_xhigh_po_0p35 L=50 mult=1
**** begin user architecture code

* ngspice commands
.options savecurrents
.include test_analog.save
.control
save all
op
print @m.x2.xm5.msky130_fd_pr__nfet_01v8[vth]
write test_analog.raw
* quit 0
.endc

**** end user architecture code
.ends

* expanding   symbol:  sky130_tests/simulate_ff.sym # of pins=0
** sym_path: /pdk/sky130A/libs.tech/xschem/sky130_tests/simulate_ff.sym
** sch_path: /pdk/sky130A/libs.tech/xschem/sky130_tests/simulate_ff.sch
.subckt simulate_ff
*.ipin CLEAR_
*.ipin CLK
x28 B[3] net4 net3 VGND VNB VPB VPWR net5 BNEXT[3] sky130_fd_sc_hd__fa_1
x33 B[2] net4 net2 VGND VNB VPB VPWR net3 BNEXT[2] sky130_fd_sc_hd__fa_1
x34 B[1] net4 net1 VGND VNB VPB VPWR net2 BNEXT[1] sky130_fd_sc_hd__fa_1
x35 B[0] CLEAR_ net4 VGND VNB VPB VPWR net1 BNEXT[0] sky130_fd_sc_hd__fa_1
x36 CLK net6 CLEAR_ VGND VNB VPB VPWR B[3] sky130_fd_sc_hd__dfrtp_1
x37 CLK net7 CLEAR_ VGND VNB VPB VPWR B[2] sky130_fd_sc_hd__dfrtp_1
x53 CLK net8 CLEAR_ VGND VNB VPB VPWR B[1] sky130_fd_sc_hd__dfrtp_1
x54 CLK net9 CLEAR_ VGND VNB VPB VPWR B[0] sky130_fd_sc_hd__dfrtp_1
x55 CLEAR_ VGND VNB VPB VPWR net4 sky130_fd_sc_hd__inv_2
* noconn #net5
x59 BNEXT[3] net10 VGND VNB VPB VPWR net6 sky130_fd_sc_hd__and2_1
x60 BNEXT[2] net10 VGND VNB VPB VPWR net7 sky130_fd_sc_hd__and2_1
x61 BNEXT[1] net10 VGND VNB VPB VPWR net8 sky130_fd_sc_hd__and2_1
x62 BNEXT[0] net10 VGND VNB VPB VPWR net9 sky130_fd_sc_hd__and2_1
x1 net10 VGND VNB VPB VPWR R sky130_fd_sc_hd__inv_2
x22 B[3] VGND VNB VPB VPWR net11 sky130_fd_sc_hd__inv_2
x23 B[2] VGND VNB VPB VPWR net12 sky130_fd_sc_hd__inv_2
x24 B[1] VGND VNB VPB VPWR net14 sky130_fd_sc_hd__inv_2
x25 B[0] VGND VNB VPB VPWR net13 sky130_fd_sc_hd__inv_2
x21 net11 net12 B[1] net13 VGND VNB VPB VPWR S[5] sky130_fd_sc_hd__nand4_1
x38 net17 net18 net19 net20 VGND VNB VPB VPWR S[1] sky130_fd_sc_hd__and4_1
x39 net11 net12 net14 B[0] VGND VNB VPB VPWR net15 sky130_fd_sc_hd__nand4_1
x40 net11 B[2] net14 net13 VGND VNB VPB VPWR net16 sky130_fd_sc_hd__nand4_1
x41 net15 net16 VGND VNB VPB VPWR S[0] sky130_fd_sc_hd__and2_1
x42 net11 net12 B[1] net13 VGND VNB VPB VPWR net18 sky130_fd_sc_hd__nand4_1
x43 net11 net12 B[1] B[0] VGND VNB VPB VPWR net19 sky130_fd_sc_hd__nand4_1
x44 net11 B[2] B[1] B[0] VGND VNB VPB VPWR net20 sky130_fd_sc_hd__nand4_1
x45 net11 net12 net14 B[0] VGND VNB VPB VPWR net17 sky130_fd_sc_hd__nand4_1
x46 net11 B[2] net14 B[0] VGND VNB VPB VPWR net21 sky130_fd_sc_hd__nand4_1
x47 net11 B[2] B[1] net13 VGND VNB VPB VPWR net22 sky130_fd_sc_hd__nand4_1
x48 net21 net22 VGND VNB VPB VPWR S[2] sky130_fd_sc_hd__and2_1
x49 net11 net12 net14 net13 VGND VNB VPB VPWR net23 sky130_fd_sc_hd__nand4_1
x50 net11 net12 net14 B[0] VGND VNB VPB VPWR net24 sky130_fd_sc_hd__nand4_1
x51 net11 B[2] B[1] B[0] VGND VNB VPB VPWR net25 sky130_fd_sc_hd__nand4_1
x52 net23 net24 net25 VGND VNB VPB VPWR S[3] sky130_fd_sc_hd__and3_1
x18 net11 net12 net14 net13 VGND VNB VPB VPWR net26 sky130_fd_sc_hd__and4_1
x19 net11 net12 B[1] net13 VGND VNB VPB VPWR net27 sky130_fd_sc_hd__and4_1
x20 net11 B[2] B[1] net13 VGND VNB VPB VPWR net28 sky130_fd_sc_hd__and4_1
x26 B[3] net12 net14 net13 VGND VNB VPB VPWR net29 sky130_fd_sc_hd__and4_1
x27 net26 net27 net28 net29 VGND VNB VPB VPWR S[4] sky130_fd_sc_hd__or4_1
x29 net11 net12 net14 B[0] VGND VNB VPB VPWR net30 sky130_fd_sc_hd__nand4_1
x30 net11 B[2] net14 net13 VGND VNB VPB VPWR net31 sky130_fd_sc_hd__nand4_1
x31 net11 B[2] B[1] B[0] VGND VNB VPB VPWR net32 sky130_fd_sc_hd__nand4_1
x32 net30 net31 net32 VGND VNB VPB VPWR S[6] sky130_fd_sc_hd__and3_1
x3 BNEXT[1] BNEXT[3] VGND VNB VPB VPWR net10 sky130_fd_sc_hd__nand2_1
.ends

* expanding   symbol:  sky130_tests/tb_ft_test.sym # of pins=0
** sym_path: /pdk/sky130A/libs.tech/xschem/sky130_tests/tb_ft_test.sym
** sch_path: /pdk/sky130A/libs.tech/xschem/sky130_tests/tb_ft_test.sch
.subckt tb_ft_test
XM_DUT net1 net3 GND GND sky130_fd_pr__nfet_01v8_lvt L=0.15 W=10 nf=1 ad=2.9 as=2.9 pd=20.58 ps=20.58 nrd=0.029 nrs=0.029 sa=0
+ sb=0 sd=0 mult=1
Idref GND G dc 3m AC 1 0
**** begin user architecture code

.include tb_ft_test.save
* .options filetype=ascii
.option savecurrents
.save all
.control
*dc Idref 0.1e-3 10e-3 0.1e-3
let n_idx = 59
let start_iref = 0.1e-3
let stop_iref = 6e-3
let delta_iref = (stop_iref - start_iref) / n_idx
let iref_act = start_iref
let idx = 0
*loop
while iref_act le stop_iref
  alter idref iref_act
  op
  let gm = @m.xm_dut.msky130_fd_pr__nfet_01v8_lvt[gm]
  let ids = @m.xm_dut.msky130_fd_pr__nfet_01v8_lvt[id]
  let cgg =  @m.xm_dut.msky130_fd_pr__nfet_01v8_lvt[cgg]
  let cgso =  @m.xm_dut.msky130_fd_pr__nfet_01v8_lvt[cgso]
  let cgdo =  @m.xm_dut.msky130_fd_pr__nfet_01v8_lvt[cgdo]
  let ft = gm/(2*pi*(cgg + cgso + cgdo))

  setscale iref_act
  settype current iref_act
  write tb_ft_test.raw
  set appendwrite

  let iref_act = iref_act + delta_iref
  let idx = idx + 1
end

ac dec 10 1k 100G
remzerovec
write tb_ft_test.raw

.endc
.end

**** end user architecture code
Vd D net1 0
.save i(vd)
Vg G net3 0
.save i(vg)
XM_BIAS G G GND GND sky130_fd_pr__nfet_01v8_lvt L=0.15 W=10 nf=1 ad=2.9 as=2.9 pd=20.58 ps=20.58 nrd=0.029 nrs=0.029 sa=0 sb=0
+ sd=0 mult=1
L2 net2 G 1
C1 net2 GND 1
E1 D GND net2 GND 1
.ends

* expanding   symbol:  sky130_tests/tb_ft_test_2.sym # of pins=0
** sym_path: /pdk/sky130A/libs.tech/xschem/sky130_tests/tb_ft_test_2.sym
** sch_path: /pdk/sky130A/libs.tech/xschem/sky130_tests/tb_ft_test_2.sch
.subckt tb_ft_test_2
VDS D GND 1.5
**** begin user architecture code

* this experimental option enables mos model bin
* selection based on W/NF instead of W
.option wnflag=1
.options method=gear savecurrents
.save all
.include tb_ft_test_2.save
.control
  save all
* save @m.xm1.msky130_fd_pr__rf_nfet_01v8_lvt_bm02w5p00l0p18[gm]
*  save @m.xm1.msky130_fd_pr__nfet_01v8_lvt[gm]
  op
  write tb_ft_test_2.raw
  tran 0.001n 2n
  set appendwrite
  write tb_ft_test_2.raw
  ac dec 10 1000 1000G
  set appendwrite
  write tb_ft_test_2.raw
  setplot tran1
  plot i(vg) i(vd)
  setplot ac1
  plot db(i(vd)/i(vg))
.endc

**** end user architecture code
VGS net4 GND 1
Vd net7 net5 0
.save i(vd)
L1 G net4 1m
Vg G net3 0
.save i(vg)
L2 net2 net5 1m
C1 net2 net7 1m
C2 G net6 1m
VGS1 net6 GND ac 1 0 sin(0 0.01 10G)
Vd_dc D net2 0
.save i(vd_dc)
.save v(g)
.save v(d)
Vb net1 GND 0
.save i(vb)
XM2 GND GND GND GND sky130_fd_pr__rf_nfet_01v8_lvt_bM02W5p00L0p18 L=0.18 W=5.05 nf=1 ad=1.4645 as=1.4645 pd=10.68 ps=10.68
+ nrd=0.0574257425742574 nrs=0.0574257425742574 sa=0 sb=0 sd=0 mult=1
XM3 GND GND GND GND sky130_fd_pr__nfet_01v8_lvt L=0.18 W=5.05 nf=1 ad=1.4645 as=1.4645 pd=10.68 ps=10.68 nrd=0.0574257425742574
+ nrs=0.0574257425742574 sa=0 sb=0 sd=0 mult=1
XM1 net5 net3 GND net1 sky130_fd_pr__nfet_01v8_lvt L=0.18 W=5.05 nf=1 ad=1.4645 as=1.4645 pd=10.68 ps=10.68 nrd=0.0574257425742574
+ nrs=0.0574257425742574 sa=0 sb=0 sd=0 mult=1
XM4 GND D GND GND sky130_fd_pr__nfet_01v8_lvt L=0.18 W=5.05 nf=1 ad=1.4645 as=1.4645 pd=10.68 ps=10.68 nrd=0.0574257425742574
+ nrs=0.0574257425742574 sa=0 sb=0 sd=0 mult=1
.ends

* expanding   symbol:  sky130_tests/tb_bandgap.sym # of pins=0
** sym_path: /pdk/sky130A/libs.tech/xschem/sky130_tests/tb_bandgap.sym
** sch_path: /pdk/sky130A/libs.tech/xschem/sky130_tests/tb_bandgap.sch
.subckt tb_bandgap
x1 START CLK EN_N VBG VCC VSS bandgap
V1 EN_N VSS 0
V2 net1 VSS dc 'VCC' pwl 0 0 1u 0 4u 'VCC'
V3 VSS 0 0
E5 TEMPERAT VSS VOL=' temper '
V4 START VSS pwl 0 'VCC' 25u 'VCC' 25.001u 0
V5 CLK VSS dc 0 pulse 'VCC' 0 25u 1n 1n 27000n 30000n
.save v(vbg)
.save v(start)
.save v(clk)
.save v(en_n)
.save v(vcc)
.save v(vss)
.save v(temperat)
VCC net1 VCC 0
.save i(vcc)
.ends

* expanding   symbol:  sky130_tests/logic_ngspice.sym # of pins=0
** sym_path: /pdk/sky130A/libs.tech/xschem/sky130_tests/logic_ngspice.sym
** sch_path: /pdk/sky130A/libs.tech/xschem/sky130_tests/logic_ngspice.sch
.subckt logic_ngspice
x1 AA BB ZN VCC VSS lvnand WidthN=1 LenN=0.15 WidthP=1 LenP=0.15
V1 VCC VSS 1.8
V2 AA VSS pulse 0 1.8 0 1n 1n 10n 20n
V3 BB VSS pulse 0 1.8 0 1n 1n 13n 26n
x3 ZZ ZN VCC VSS not W_N=1 L_N=0.15 W_P=2 L_P=0.15
V4 VSS 0 0
.ends

* expanding   symbol:  sky130_tests/test_carry_lookahead.sym # of pins=0
** sym_path: /pdk/sky130A/libs.tech/xschem/sky130_tests/test_carry_lookahead.sym
** sch_path: /pdk/sky130A/libs.tech/xschem/sky130_tests/test_carry_lookahead.sch
.subckt test_carry_lookahead
*.ipin
*+ A[255],A[254],A[253],A[252],A[251],A[250],A[249],A[248],A[247],A[246],A[245],A[244],A[243],A[242],A[241],A[240],A[239],A[238],A[237],A[236],A[235],A[234],A[233],A[232],A[231],A[230],A[229],A[228],A[227],A[226],A[225],A[224],A[223],A[222],A[221],A[220],A[219],A[218],A[217],A[216],A[215],A[214],A[213],A[212],A[211],A[210],A[209],A[208],A[207],A[206],A[205],A[204],A[203],A[202],A[201],A[200],A[199],A[198],A[197],A[196],A[195],A[194],A[193],A[192],A[191],A[190],A[189],A[188],A[187],A[186],A[185],A[184],A[183],A[182],A[181],A[180],A[179],A[178],A[177],A[176],A[175],A[174],A[173],A[172],A[171],A[170],A[169],A[168],A[167],A[166],A[165],A[164],A[163],A[162],A[161],A[160],A[159],A[158],A[157],A[156],A[155],A[154],A[153],A[152],A[151],A[150],A[149],A[148],A[147],A[146],A[145],A[144],A[143],A[142],A[141],A[140],A[139],A[138],A[137],A[136],A[135],A[134],A[133],A[132],A[131],A[130],A[129],A[128],A[127],A[126],A[125],A[124],A[123],A[122],A[121],A[120],A[119],A[118],A[117],A[116],A[115],A[114],A[113],A[112],A[111],A[110],A[109],A[108],A[107],A[106],A[105],A[104],A[103],A[102],A[101],A[100],A[99],A[98],A[97],A[96],A[95],A[94],A[93],A[92],A[91],A[90],A[89],A[88],A[87],A[86],A[85],A[84],A[83],A[82],A[81],A[80],A[79],A[78],A[77],A[76],A[75],A[74],A[73],A[72],A[71],A[70],A[69],A[68],A[67],A[66],A[65],A[64],A[63],A[62],A[61],A[60],A[59],A[58],A[57],A[56],A[55],A[54],A[53],A[52],A[51],A[50],A[49],A[48],A[47],A[46],A[45],A[44],A[43],A[42],A[41],A[40],A[39],A[38],A[37],A[36],A[35],A[34],A[33],A[32],A[31],A[30],A[29],A[28],A[27],A[26],A[25],A[24],A[23],A[22],A[21],A[20],A[19],A[18],A[17],A[16],A[15],A[14],A[13],A[12],A[11],A[10],A[9],A[8],A[7],A[6],A[5],A[4],A[3],A[2],A[1],A[0]
*.ipin
*+ B[255],B[254],B[253],B[252],B[251],B[250],B[249],B[248],B[247],B[246],B[245],B[244],B[243],B[242],B[241],B[240],B[239],B[238],B[237],B[236],B[235],B[234],B[233],B[232],B[231],B[230],B[229],B[228],B[227],B[226],B[225],B[224],B[223],B[222],B[221],B[220],B[219],B[218],B[217],B[216],B[215],B[214],B[213],B[212],B[211],B[210],B[209],B[208],B[207],B[206],B[205],B[204],B[203],B[202],B[201],B[200],B[199],B[198],B[197],B[196],B[195],B[194],B[193],B[192],B[191],B[190],B[189],B[188],B[187],B[186],B[185],B[184],B[183],B[182],B[181],B[180],B[179],B[178],B[177],B[176],B[175],B[174],B[173],B[172],B[171],B[170],B[169],B[168],B[167],B[166],B[165],B[164],B[163],B[162],B[161],B[160],B[159],B[158],B[157],B[156],B[155],B[154],B[153],B[152],B[151],B[150],B[149],B[148],B[147],B[146],B[145],B[144],B[143],B[142],B[141],B[140],B[139],B[138],B[137],B[136],B[135],B[134],B[133],B[132],B[131],B[130],B[129],B[128],B[127],B[126],B[125],B[124],B[123],B[122],B[121],B[120],B[119],B[118],B[117],B[116],B[115],B[114],B[113],B[112],B[111],B[110],B[109],B[108],B[107],B[106],B[105],B[104],B[103],B[102],B[101],B[100],B[99],B[98],B[97],B[96],B[95],B[94],B[93],B[92],B[91],B[90],B[89],B[88],B[87],B[86],B[85],B[84],B[83],B[82],B[81],B[80],B[79],B[78],B[77],B[76],B[75],B[74],B[73],B[72],B[71],B[70],B[69],B[68],B[67],B[66],B[65],B[64],B[63],B[62],B[61],B[60],B[59],B[58],B[57],B[56],B[55],B[54],B[53],B[52],B[51],B[50],B[49],B[48],B[47],B[46],B[45],B[44],B[43],B[42],B[41],B[40],B[39],B[38],B[37],B[36],B[35],B[34],B[33],B[32],B[31],B[30],B[29],B[28],B[27],B[26],B[25],B[24],B[23],B[22],B[21],B[20],B[19],B[18],B[17],B[16],B[15],B[14],B[13],B[12],B[11],B[10],B[9],B[8],B[7],B[6],B[5],B[4],B[3],B[2],B[1],B[0]
*.ipin CIN
xaddcarry256[255] A[255] B[255] CARRY0[254] VSS VSS VCC VCC CARRY0[255] S0[255] sky130_fd_sc_hd__fah_1
xaddcarry256[254] A[254] B[254] CARRY0[253] VSS VSS VCC VCC CARRY0[254] S0[254] sky130_fd_sc_hd__fah_1
xaddcarry256[253] A[253] B[253] CARRY0[252] VSS VSS VCC VCC CARRY0[253] S0[253] sky130_fd_sc_hd__fah_1
xaddcarry256[252] A[252] B[252] CARRY0[251] VSS VSS VCC VCC CARRY0[252] S0[252] sky130_fd_sc_hd__fah_1
xaddcarry256[251] A[251] B[251] CARRY0[250] VSS VSS VCC VCC CARRY0[251] S0[251] sky130_fd_sc_hd__fah_1
xaddcarry256[250] A[250] B[250] CARRY0[249] VSS VSS VCC VCC CARRY0[250] S0[250] sky130_fd_sc_hd__fah_1
xaddcarry256[249] A[249] B[249] CARRY0[248] VSS VSS VCC VCC CARRY0[249] S0[249] sky130_fd_sc_hd__fah_1
xaddcarry256[248] A[248] B[248] CARRY0[247] VSS VSS VCC VCC CARRY0[248] S0[248] sky130_fd_sc_hd__fah_1
xaddcarry256[247] A[247] B[247] CARRY0[246] VSS VSS VCC VCC CARRY0[247] S0[247] sky130_fd_sc_hd__fah_1
xaddcarry256[246] A[246] B[246] CARRY0[245] VSS VSS VCC VCC CARRY0[246] S0[246] sky130_fd_sc_hd__fah_1
xaddcarry256[245] A[245] B[245] CARRY0[244] VSS VSS VCC VCC CARRY0[245] S0[245] sky130_fd_sc_hd__fah_1
xaddcarry256[244] A[244] B[244] CARRY0[243] VSS VSS VCC VCC CARRY0[244] S0[244] sky130_fd_sc_hd__fah_1
xaddcarry256[243] A[243] B[243] CARRY0[242] VSS VSS VCC VCC CARRY0[243] S0[243] sky130_fd_sc_hd__fah_1
xaddcarry256[242] A[242] B[242] CARRY0[241] VSS VSS VCC VCC CARRY0[242] S0[242] sky130_fd_sc_hd__fah_1
xaddcarry256[241] A[241] B[241] CARRY0[240] VSS VSS VCC VCC CARRY0[241] S0[241] sky130_fd_sc_hd__fah_1
xaddcarry256[240] A[240] B[240] CARRY0[239] VSS VSS VCC VCC CARRY0[240] S0[240] sky130_fd_sc_hd__fah_1
xaddcarry256[239] A[239] B[239] CARRY0[238] VSS VSS VCC VCC CARRY0[239] S0[239] sky130_fd_sc_hd__fah_1
xaddcarry256[238] A[238] B[238] CARRY0[237] VSS VSS VCC VCC CARRY0[238] S0[238] sky130_fd_sc_hd__fah_1
xaddcarry256[237] A[237] B[237] CARRY0[236] VSS VSS VCC VCC CARRY0[237] S0[237] sky130_fd_sc_hd__fah_1
xaddcarry256[236] A[236] B[236] CARRY0[235] VSS VSS VCC VCC CARRY0[236] S0[236] sky130_fd_sc_hd__fah_1
xaddcarry256[235] A[235] B[235] CARRY0[234] VSS VSS VCC VCC CARRY0[235] S0[235] sky130_fd_sc_hd__fah_1
xaddcarry256[234] A[234] B[234] CARRY0[233] VSS VSS VCC VCC CARRY0[234] S0[234] sky130_fd_sc_hd__fah_1
xaddcarry256[233] A[233] B[233] CARRY0[232] VSS VSS VCC VCC CARRY0[233] S0[233] sky130_fd_sc_hd__fah_1
xaddcarry256[232] A[232] B[232] CARRY0[231] VSS VSS VCC VCC CARRY0[232] S0[232] sky130_fd_sc_hd__fah_1
xaddcarry256[231] A[231] B[231] CARRY0[230] VSS VSS VCC VCC CARRY0[231] S0[231] sky130_fd_sc_hd__fah_1
xaddcarry256[230] A[230] B[230] CARRY0[229] VSS VSS VCC VCC CARRY0[230] S0[230] sky130_fd_sc_hd__fah_1
xaddcarry256[229] A[229] B[229] CARRY0[228] VSS VSS VCC VCC CARRY0[229] S0[229] sky130_fd_sc_hd__fah_1
xaddcarry256[228] A[228] B[228] CARRY0[227] VSS VSS VCC VCC CARRY0[228] S0[228] sky130_fd_sc_hd__fah_1
xaddcarry256[227] A[227] B[227] CARRY0[226] VSS VSS VCC VCC CARRY0[227] S0[227] sky130_fd_sc_hd__fah_1
xaddcarry256[226] A[226] B[226] CARRY0[225] VSS VSS VCC VCC CARRY0[226] S0[226] sky130_fd_sc_hd__fah_1
xaddcarry256[225] A[225] B[225] CARRY0[224] VSS VSS VCC VCC CARRY0[225] S0[225] sky130_fd_sc_hd__fah_1
xaddcarry256[224] A[224] B[224] CARRY0[223] VSS VSS VCC VCC CARRY0[224] S0[224] sky130_fd_sc_hd__fah_1
xaddcarry256[223] A[223] B[223] CARRY0[222] VSS VSS VCC VCC CARRY0[223] S0[223] sky130_fd_sc_hd__fah_1
xaddcarry256[222] A[222] B[222] CARRY0[221] VSS VSS VCC VCC CARRY0[222] S0[222] sky130_fd_sc_hd__fah_1
xaddcarry256[221] A[221] B[221] CARRY0[220] VSS VSS VCC VCC CARRY0[221] S0[221] sky130_fd_sc_hd__fah_1
xaddcarry256[220] A[220] B[220] CARRY0[219] VSS VSS VCC VCC CARRY0[220] S0[220] sky130_fd_sc_hd__fah_1
xaddcarry256[219] A[219] B[219] CARRY0[218] VSS VSS VCC VCC CARRY0[219] S0[219] sky130_fd_sc_hd__fah_1
xaddcarry256[218] A[218] B[218] CARRY0[217] VSS VSS VCC VCC CARRY0[218] S0[218] sky130_fd_sc_hd__fah_1
xaddcarry256[217] A[217] B[217] CARRY0[216] VSS VSS VCC VCC CARRY0[217] S0[217] sky130_fd_sc_hd__fah_1
xaddcarry256[216] A[216] B[216] CARRY0[215] VSS VSS VCC VCC CARRY0[216] S0[216] sky130_fd_sc_hd__fah_1
xaddcarry256[215] A[215] B[215] CARRY0[214] VSS VSS VCC VCC CARRY0[215] S0[215] sky130_fd_sc_hd__fah_1
xaddcarry256[214] A[214] B[214] CARRY0[213] VSS VSS VCC VCC CARRY0[214] S0[214] sky130_fd_sc_hd__fah_1
xaddcarry256[213] A[213] B[213] CARRY0[212] VSS VSS VCC VCC CARRY0[213] S0[213] sky130_fd_sc_hd__fah_1
xaddcarry256[212] A[212] B[212] CARRY0[211] VSS VSS VCC VCC CARRY0[212] S0[212] sky130_fd_sc_hd__fah_1
xaddcarry256[211] A[211] B[211] CARRY0[210] VSS VSS VCC VCC CARRY0[211] S0[211] sky130_fd_sc_hd__fah_1
xaddcarry256[210] A[210] B[210] CARRY0[209] VSS VSS VCC VCC CARRY0[210] S0[210] sky130_fd_sc_hd__fah_1
xaddcarry256[209] A[209] B[209] CARRY0[208] VSS VSS VCC VCC CARRY0[209] S0[209] sky130_fd_sc_hd__fah_1
xaddcarry256[208] A[208] B[208] CARRY0[207] VSS VSS VCC VCC CARRY0[208] S0[208] sky130_fd_sc_hd__fah_1
xaddcarry256[207] A[207] B[207] CARRY0[206] VSS VSS VCC VCC CARRY0[207] S0[207] sky130_fd_sc_hd__fah_1
xaddcarry256[206] A[206] B[206] CARRY0[205] VSS VSS VCC VCC CARRY0[206] S0[206] sky130_fd_sc_hd__fah_1
xaddcarry256[205] A[205] B[205] CARRY0[204] VSS VSS VCC VCC CARRY0[205] S0[205] sky130_fd_sc_hd__fah_1
xaddcarry256[204] A[204] B[204] CARRY0[203] VSS VSS VCC VCC CARRY0[204] S0[204] sky130_fd_sc_hd__fah_1
xaddcarry256[203] A[203] B[203] CARRY0[202] VSS VSS VCC VCC CARRY0[203] S0[203] sky130_fd_sc_hd__fah_1
xaddcarry256[202] A[202] B[202] CARRY0[201] VSS VSS VCC VCC CARRY0[202] S0[202] sky130_fd_sc_hd__fah_1
xaddcarry256[201] A[201] B[201] CARRY0[200] VSS VSS VCC VCC CARRY0[201] S0[201] sky130_fd_sc_hd__fah_1
xaddcarry256[200] A[200] B[200] CARRY0[199] VSS VSS VCC VCC CARRY0[200] S0[200] sky130_fd_sc_hd__fah_1
xaddcarry256[199] A[199] B[199] CARRY0[198] VSS VSS VCC VCC CARRY0[199] S0[199] sky130_fd_sc_hd__fah_1
xaddcarry256[198] A[198] B[198] CARRY0[197] VSS VSS VCC VCC CARRY0[198] S0[198] sky130_fd_sc_hd__fah_1
xaddcarry256[197] A[197] B[197] CARRY0[196] VSS VSS VCC VCC CARRY0[197] S0[197] sky130_fd_sc_hd__fah_1
xaddcarry256[196] A[196] B[196] CARRY0[195] VSS VSS VCC VCC CARRY0[196] S0[196] sky130_fd_sc_hd__fah_1
xaddcarry256[195] A[195] B[195] CARRY0[194] VSS VSS VCC VCC CARRY0[195] S0[195] sky130_fd_sc_hd__fah_1
xaddcarry256[194] A[194] B[194] CARRY0[193] VSS VSS VCC VCC CARRY0[194] S0[194] sky130_fd_sc_hd__fah_1
xaddcarry256[193] A[193] B[193] CARRY0[192] VSS VSS VCC VCC CARRY0[193] S0[193] sky130_fd_sc_hd__fah_1
xaddcarry256[192] A[192] B[192] CARRY0[191] VSS VSS VCC VCC CARRY0[192] S0[192] sky130_fd_sc_hd__fah_1
xaddcarry256[191] A[191] B[191] CARRY0[190] VSS VSS VCC VCC CARRY0[191] S0[191] sky130_fd_sc_hd__fah_1
xaddcarry256[190] A[190] B[190] CARRY0[189] VSS VSS VCC VCC CARRY0[190] S0[190] sky130_fd_sc_hd__fah_1
xaddcarry256[189] A[189] B[189] CARRY0[188] VSS VSS VCC VCC CARRY0[189] S0[189] sky130_fd_sc_hd__fah_1
xaddcarry256[188] A[188] B[188] CARRY0[187] VSS VSS VCC VCC CARRY0[188] S0[188] sky130_fd_sc_hd__fah_1
xaddcarry256[187] A[187] B[187] CARRY0[186] VSS VSS VCC VCC CARRY0[187] S0[187] sky130_fd_sc_hd__fah_1
xaddcarry256[186] A[186] B[186] CARRY0[185] VSS VSS VCC VCC CARRY0[186] S0[186] sky130_fd_sc_hd__fah_1
xaddcarry256[185] A[185] B[185] CARRY0[184] VSS VSS VCC VCC CARRY0[185] S0[185] sky130_fd_sc_hd__fah_1
xaddcarry256[184] A[184] B[184] CARRY0[183] VSS VSS VCC VCC CARRY0[184] S0[184] sky130_fd_sc_hd__fah_1
xaddcarry256[183] A[183] B[183] CARRY0[182] VSS VSS VCC VCC CARRY0[183] S0[183] sky130_fd_sc_hd__fah_1
xaddcarry256[182] A[182] B[182] CARRY0[181] VSS VSS VCC VCC CARRY0[182] S0[182] sky130_fd_sc_hd__fah_1
xaddcarry256[181] A[181] B[181] CARRY0[180] VSS VSS VCC VCC CARRY0[181] S0[181] sky130_fd_sc_hd__fah_1
xaddcarry256[180] A[180] B[180] CARRY0[179] VSS VSS VCC VCC CARRY0[180] S0[180] sky130_fd_sc_hd__fah_1
xaddcarry256[179] A[179] B[179] CARRY0[178] VSS VSS VCC VCC CARRY0[179] S0[179] sky130_fd_sc_hd__fah_1
xaddcarry256[178] A[178] B[178] CARRY0[177] VSS VSS VCC VCC CARRY0[178] S0[178] sky130_fd_sc_hd__fah_1
xaddcarry256[177] A[177] B[177] CARRY0[176] VSS VSS VCC VCC CARRY0[177] S0[177] sky130_fd_sc_hd__fah_1
xaddcarry256[176] A[176] B[176] CARRY0[175] VSS VSS VCC VCC CARRY0[176] S0[176] sky130_fd_sc_hd__fah_1
xaddcarry256[175] A[175] B[175] CARRY0[174] VSS VSS VCC VCC CARRY0[175] S0[175] sky130_fd_sc_hd__fah_1
xaddcarry256[174] A[174] B[174] CARRY0[173] VSS VSS VCC VCC CARRY0[174] S0[174] sky130_fd_sc_hd__fah_1
xaddcarry256[173] A[173] B[173] CARRY0[172] VSS VSS VCC VCC CARRY0[173] S0[173] sky130_fd_sc_hd__fah_1
xaddcarry256[172] A[172] B[172] CARRY0[171] VSS VSS VCC VCC CARRY0[172] S0[172] sky130_fd_sc_hd__fah_1
xaddcarry256[171] A[171] B[171] CARRY0[170] VSS VSS VCC VCC CARRY0[171] S0[171] sky130_fd_sc_hd__fah_1
xaddcarry256[170] A[170] B[170] CARRY0[169] VSS VSS VCC VCC CARRY0[170] S0[170] sky130_fd_sc_hd__fah_1
xaddcarry256[169] A[169] B[169] CARRY0[168] VSS VSS VCC VCC CARRY0[169] S0[169] sky130_fd_sc_hd__fah_1
xaddcarry256[168] A[168] B[168] CARRY0[167] VSS VSS VCC VCC CARRY0[168] S0[168] sky130_fd_sc_hd__fah_1
xaddcarry256[167] A[167] B[167] CARRY0[166] VSS VSS VCC VCC CARRY0[167] S0[167] sky130_fd_sc_hd__fah_1
xaddcarry256[166] A[166] B[166] CARRY0[165] VSS VSS VCC VCC CARRY0[166] S0[166] sky130_fd_sc_hd__fah_1
xaddcarry256[165] A[165] B[165] CARRY0[164] VSS VSS VCC VCC CARRY0[165] S0[165] sky130_fd_sc_hd__fah_1
xaddcarry256[164] A[164] B[164] CARRY0[163] VSS VSS VCC VCC CARRY0[164] S0[164] sky130_fd_sc_hd__fah_1
xaddcarry256[163] A[163] B[163] CARRY0[162] VSS VSS VCC VCC CARRY0[163] S0[163] sky130_fd_sc_hd__fah_1
xaddcarry256[162] A[162] B[162] CARRY0[161] VSS VSS VCC VCC CARRY0[162] S0[162] sky130_fd_sc_hd__fah_1
xaddcarry256[161] A[161] B[161] CARRY0[160] VSS VSS VCC VCC CARRY0[161] S0[161] sky130_fd_sc_hd__fah_1
xaddcarry256[160] A[160] B[160] CARRY0[159] VSS VSS VCC VCC CARRY0[160] S0[160] sky130_fd_sc_hd__fah_1
xaddcarry256[159] A[159] B[159] CARRY0[158] VSS VSS VCC VCC CARRY0[159] S0[159] sky130_fd_sc_hd__fah_1
xaddcarry256[158] A[158] B[158] CARRY0[157] VSS VSS VCC VCC CARRY0[158] S0[158] sky130_fd_sc_hd__fah_1
xaddcarry256[157] A[157] B[157] CARRY0[156] VSS VSS VCC VCC CARRY0[157] S0[157] sky130_fd_sc_hd__fah_1
xaddcarry256[156] A[156] B[156] CARRY0[155] VSS VSS VCC VCC CARRY0[156] S0[156] sky130_fd_sc_hd__fah_1
xaddcarry256[155] A[155] B[155] CARRY0[154] VSS VSS VCC VCC CARRY0[155] S0[155] sky130_fd_sc_hd__fah_1
xaddcarry256[154] A[154] B[154] CARRY0[153] VSS VSS VCC VCC CARRY0[154] S0[154] sky130_fd_sc_hd__fah_1
xaddcarry256[153] A[153] B[153] CARRY0[152] VSS VSS VCC VCC CARRY0[153] S0[153] sky130_fd_sc_hd__fah_1
xaddcarry256[152] A[152] B[152] CARRY0[151] VSS VSS VCC VCC CARRY0[152] S0[152] sky130_fd_sc_hd__fah_1
xaddcarry256[151] A[151] B[151] CARRY0[150] VSS VSS VCC VCC CARRY0[151] S0[151] sky130_fd_sc_hd__fah_1
xaddcarry256[150] A[150] B[150] CARRY0[149] VSS VSS VCC VCC CARRY0[150] S0[150] sky130_fd_sc_hd__fah_1
xaddcarry256[149] A[149] B[149] CARRY0[148] VSS VSS VCC VCC CARRY0[149] S0[149] sky130_fd_sc_hd__fah_1
xaddcarry256[148] A[148] B[148] CARRY0[147] VSS VSS VCC VCC CARRY0[148] S0[148] sky130_fd_sc_hd__fah_1
xaddcarry256[147] A[147] B[147] CARRY0[146] VSS VSS VCC VCC CARRY0[147] S0[147] sky130_fd_sc_hd__fah_1
xaddcarry256[146] A[146] B[146] CARRY0[145] VSS VSS VCC VCC CARRY0[146] S0[146] sky130_fd_sc_hd__fah_1
xaddcarry256[145] A[145] B[145] CARRY0[144] VSS VSS VCC VCC CARRY0[145] S0[145] sky130_fd_sc_hd__fah_1
xaddcarry256[144] A[144] B[144] CARRY0[143] VSS VSS VCC VCC CARRY0[144] S0[144] sky130_fd_sc_hd__fah_1
xaddcarry256[143] A[143] B[143] CARRY0[142] VSS VSS VCC VCC CARRY0[143] S0[143] sky130_fd_sc_hd__fah_1
xaddcarry256[142] A[142] B[142] CARRY0[141] VSS VSS VCC VCC CARRY0[142] S0[142] sky130_fd_sc_hd__fah_1
xaddcarry256[141] A[141] B[141] CARRY0[140] VSS VSS VCC VCC CARRY0[141] S0[141] sky130_fd_sc_hd__fah_1
xaddcarry256[140] A[140] B[140] CARRY0[139] VSS VSS VCC VCC CARRY0[140] S0[140] sky130_fd_sc_hd__fah_1
xaddcarry256[139] A[139] B[139] CARRY0[138] VSS VSS VCC VCC CARRY0[139] S0[139] sky130_fd_sc_hd__fah_1
xaddcarry256[138] A[138] B[138] CARRY0[137] VSS VSS VCC VCC CARRY0[138] S0[138] sky130_fd_sc_hd__fah_1
xaddcarry256[137] A[137] B[137] CARRY0[136] VSS VSS VCC VCC CARRY0[137] S0[137] sky130_fd_sc_hd__fah_1
xaddcarry256[136] A[136] B[136] CARRY0[135] VSS VSS VCC VCC CARRY0[136] S0[136] sky130_fd_sc_hd__fah_1
xaddcarry256[135] A[135] B[135] CARRY0[134] VSS VSS VCC VCC CARRY0[135] S0[135] sky130_fd_sc_hd__fah_1
xaddcarry256[134] A[134] B[134] CARRY0[133] VSS VSS VCC VCC CARRY0[134] S0[134] sky130_fd_sc_hd__fah_1
xaddcarry256[133] A[133] B[133] CARRY0[132] VSS VSS VCC VCC CARRY0[133] S0[133] sky130_fd_sc_hd__fah_1
xaddcarry256[132] A[132] B[132] CARRY0[131] VSS VSS VCC VCC CARRY0[132] S0[132] sky130_fd_sc_hd__fah_1
xaddcarry256[131] A[131] B[131] CARRY0[130] VSS VSS VCC VCC CARRY0[131] S0[131] sky130_fd_sc_hd__fah_1
xaddcarry256[130] A[130] B[130] CARRY0[129] VSS VSS VCC VCC CARRY0[130] S0[130] sky130_fd_sc_hd__fah_1
xaddcarry256[129] A[129] B[129] CARRY0[128] VSS VSS VCC VCC CARRY0[129] S0[129] sky130_fd_sc_hd__fah_1
xaddcarry256[128] A[128] B[128] CARRY0[127] VSS VSS VCC VCC CARRY0[128] S0[128] sky130_fd_sc_hd__fah_1
xaddcarry256[127] A[127] B[127] CARRY0[126] VSS VSS VCC VCC CARRY0[127] S0[127] sky130_fd_sc_hd__fah_1
xaddcarry256[126] A[126] B[126] CARRY0[125] VSS VSS VCC VCC CARRY0[126] S0[126] sky130_fd_sc_hd__fah_1
xaddcarry256[125] A[125] B[125] CARRY0[124] VSS VSS VCC VCC CARRY0[125] S0[125] sky130_fd_sc_hd__fah_1
xaddcarry256[124] A[124] B[124] CARRY0[123] VSS VSS VCC VCC CARRY0[124] S0[124] sky130_fd_sc_hd__fah_1
xaddcarry256[123] A[123] B[123] CARRY0[122] VSS VSS VCC VCC CARRY0[123] S0[123] sky130_fd_sc_hd__fah_1
xaddcarry256[122] A[122] B[122] CARRY0[121] VSS VSS VCC VCC CARRY0[122] S0[122] sky130_fd_sc_hd__fah_1
xaddcarry256[121] A[121] B[121] CARRY0[120] VSS VSS VCC VCC CARRY0[121] S0[121] sky130_fd_sc_hd__fah_1
xaddcarry256[120] A[120] B[120] CARRY0[119] VSS VSS VCC VCC CARRY0[120] S0[120] sky130_fd_sc_hd__fah_1
xaddcarry256[119] A[119] B[119] CARRY0[118] VSS VSS VCC VCC CARRY0[119] S0[119] sky130_fd_sc_hd__fah_1
xaddcarry256[118] A[118] B[118] CARRY0[117] VSS VSS VCC VCC CARRY0[118] S0[118] sky130_fd_sc_hd__fah_1
xaddcarry256[117] A[117] B[117] CARRY0[116] VSS VSS VCC VCC CARRY0[117] S0[117] sky130_fd_sc_hd__fah_1
xaddcarry256[116] A[116] B[116] CARRY0[115] VSS VSS VCC VCC CARRY0[116] S0[116] sky130_fd_sc_hd__fah_1
xaddcarry256[115] A[115] B[115] CARRY0[114] VSS VSS VCC VCC CARRY0[115] S0[115] sky130_fd_sc_hd__fah_1
xaddcarry256[114] A[114] B[114] CARRY0[113] VSS VSS VCC VCC CARRY0[114] S0[114] sky130_fd_sc_hd__fah_1
xaddcarry256[113] A[113] B[113] CARRY0[112] VSS VSS VCC VCC CARRY0[113] S0[113] sky130_fd_sc_hd__fah_1
xaddcarry256[112] A[112] B[112] CARRY0[111] VSS VSS VCC VCC CARRY0[112] S0[112] sky130_fd_sc_hd__fah_1
xaddcarry256[111] A[111] B[111] CARRY0[110] VSS VSS VCC VCC CARRY0[111] S0[111] sky130_fd_sc_hd__fah_1
xaddcarry256[110] A[110] B[110] CARRY0[109] VSS VSS VCC VCC CARRY0[110] S0[110] sky130_fd_sc_hd__fah_1
xaddcarry256[109] A[109] B[109] CARRY0[108] VSS VSS VCC VCC CARRY0[109] S0[109] sky130_fd_sc_hd__fah_1
xaddcarry256[108] A[108] B[108] CARRY0[107] VSS VSS VCC VCC CARRY0[108] S0[108] sky130_fd_sc_hd__fah_1
xaddcarry256[107] A[107] B[107] CARRY0[106] VSS VSS VCC VCC CARRY0[107] S0[107] sky130_fd_sc_hd__fah_1
xaddcarry256[106] A[106] B[106] CARRY0[105] VSS VSS VCC VCC CARRY0[106] S0[106] sky130_fd_sc_hd__fah_1
xaddcarry256[105] A[105] B[105] CARRY0[104] VSS VSS VCC VCC CARRY0[105] S0[105] sky130_fd_sc_hd__fah_1
xaddcarry256[104] A[104] B[104] CARRY0[103] VSS VSS VCC VCC CARRY0[104] S0[104] sky130_fd_sc_hd__fah_1
xaddcarry256[103] A[103] B[103] CARRY0[102] VSS VSS VCC VCC CARRY0[103] S0[103] sky130_fd_sc_hd__fah_1
xaddcarry256[102] A[102] B[102] CARRY0[101] VSS VSS VCC VCC CARRY0[102] S0[102] sky130_fd_sc_hd__fah_1
xaddcarry256[101] A[101] B[101] CARRY0[100] VSS VSS VCC VCC CARRY0[101] S0[101] sky130_fd_sc_hd__fah_1
xaddcarry256[100] A[100] B[100] CARRY0[99] VSS VSS VCC VCC CARRY0[100] S0[100] sky130_fd_sc_hd__fah_1
xaddcarry256[99] A[99] B[99] CARRY0[98] VSS VSS VCC VCC CARRY0[99] S0[99] sky130_fd_sc_hd__fah_1
xaddcarry256[98] A[98] B[98] CARRY0[97] VSS VSS VCC VCC CARRY0[98] S0[98] sky130_fd_sc_hd__fah_1
xaddcarry256[97] A[97] B[97] CARRY0[96] VSS VSS VCC VCC CARRY0[97] S0[97] sky130_fd_sc_hd__fah_1
xaddcarry256[96] A[96] B[96] CARRY0[95] VSS VSS VCC VCC CARRY0[96] S0[96] sky130_fd_sc_hd__fah_1
xaddcarry256[95] A[95] B[95] CARRY0[94] VSS VSS VCC VCC CARRY0[95] S0[95] sky130_fd_sc_hd__fah_1
xaddcarry256[94] A[94] B[94] CARRY0[93] VSS VSS VCC VCC CARRY0[94] S0[94] sky130_fd_sc_hd__fah_1
xaddcarry256[93] A[93] B[93] CARRY0[92] VSS VSS VCC VCC CARRY0[93] S0[93] sky130_fd_sc_hd__fah_1
xaddcarry256[92] A[92] B[92] CARRY0[91] VSS VSS VCC VCC CARRY0[92] S0[92] sky130_fd_sc_hd__fah_1
xaddcarry256[91] A[91] B[91] CARRY0[90] VSS VSS VCC VCC CARRY0[91] S0[91] sky130_fd_sc_hd__fah_1
xaddcarry256[90] A[90] B[90] CARRY0[89] VSS VSS VCC VCC CARRY0[90] S0[90] sky130_fd_sc_hd__fah_1
xaddcarry256[89] A[89] B[89] CARRY0[88] VSS VSS VCC VCC CARRY0[89] S0[89] sky130_fd_sc_hd__fah_1
xaddcarry256[88] A[88] B[88] CARRY0[87] VSS VSS VCC VCC CARRY0[88] S0[88] sky130_fd_sc_hd__fah_1
xaddcarry256[87] A[87] B[87] CARRY0[86] VSS VSS VCC VCC CARRY0[87] S0[87] sky130_fd_sc_hd__fah_1
xaddcarry256[86] A[86] B[86] CARRY0[85] VSS VSS VCC VCC CARRY0[86] S0[86] sky130_fd_sc_hd__fah_1
xaddcarry256[85] A[85] B[85] CARRY0[84] VSS VSS VCC VCC CARRY0[85] S0[85] sky130_fd_sc_hd__fah_1
xaddcarry256[84] A[84] B[84] CARRY0[83] VSS VSS VCC VCC CARRY0[84] S0[84] sky130_fd_sc_hd__fah_1
xaddcarry256[83] A[83] B[83] CARRY0[82] VSS VSS VCC VCC CARRY0[83] S0[83] sky130_fd_sc_hd__fah_1
xaddcarry256[82] A[82] B[82] CARRY0[81] VSS VSS VCC VCC CARRY0[82] S0[82] sky130_fd_sc_hd__fah_1
xaddcarry256[81] A[81] B[81] CARRY0[80] VSS VSS VCC VCC CARRY0[81] S0[81] sky130_fd_sc_hd__fah_1
xaddcarry256[80] A[80] B[80] CARRY0[79] VSS VSS VCC VCC CARRY0[80] S0[80] sky130_fd_sc_hd__fah_1
xaddcarry256[79] A[79] B[79] CARRY0[78] VSS VSS VCC VCC CARRY0[79] S0[79] sky130_fd_sc_hd__fah_1
xaddcarry256[78] A[78] B[78] CARRY0[77] VSS VSS VCC VCC CARRY0[78] S0[78] sky130_fd_sc_hd__fah_1
xaddcarry256[77] A[77] B[77] CARRY0[76] VSS VSS VCC VCC CARRY0[77] S0[77] sky130_fd_sc_hd__fah_1
xaddcarry256[76] A[76] B[76] CARRY0[75] VSS VSS VCC VCC CARRY0[76] S0[76] sky130_fd_sc_hd__fah_1
xaddcarry256[75] A[75] B[75] CARRY0[74] VSS VSS VCC VCC CARRY0[75] S0[75] sky130_fd_sc_hd__fah_1
xaddcarry256[74] A[74] B[74] CARRY0[73] VSS VSS VCC VCC CARRY0[74] S0[74] sky130_fd_sc_hd__fah_1
xaddcarry256[73] A[73] B[73] CARRY0[72] VSS VSS VCC VCC CARRY0[73] S0[73] sky130_fd_sc_hd__fah_1
xaddcarry256[72] A[72] B[72] CARRY0[71] VSS VSS VCC VCC CARRY0[72] S0[72] sky130_fd_sc_hd__fah_1
xaddcarry256[71] A[71] B[71] CARRY0[70] VSS VSS VCC VCC CARRY0[71] S0[71] sky130_fd_sc_hd__fah_1
xaddcarry256[70] A[70] B[70] CARRY0[69] VSS VSS VCC VCC CARRY0[70] S0[70] sky130_fd_sc_hd__fah_1
xaddcarry256[69] A[69] B[69] CARRY0[68] VSS VSS VCC VCC CARRY0[69] S0[69] sky130_fd_sc_hd__fah_1
xaddcarry256[68] A[68] B[68] CARRY0[67] VSS VSS VCC VCC CARRY0[68] S0[68] sky130_fd_sc_hd__fah_1
xaddcarry256[67] A[67] B[67] CARRY0[66] VSS VSS VCC VCC CARRY0[67] S0[67] sky130_fd_sc_hd__fah_1
xaddcarry256[66] A[66] B[66] CARRY0[65] VSS VSS VCC VCC CARRY0[66] S0[66] sky130_fd_sc_hd__fah_1
xaddcarry256[65] A[65] B[65] CARRY0[64] VSS VSS VCC VCC CARRY0[65] S0[65] sky130_fd_sc_hd__fah_1
xaddcarry256[64] A[64] B[64] CARRY0[63] VSS VSS VCC VCC CARRY0[64] S0[64] sky130_fd_sc_hd__fah_1
xaddcarry256[63] A[63] B[63] CARRY0[62] VSS VSS VCC VCC CARRY0[63] S0[63] sky130_fd_sc_hd__fah_1
xaddcarry256[62] A[62] B[62] CARRY0[61] VSS VSS VCC VCC CARRY0[62] S0[62] sky130_fd_sc_hd__fah_1
xaddcarry256[61] A[61] B[61] CARRY0[60] VSS VSS VCC VCC CARRY0[61] S0[61] sky130_fd_sc_hd__fah_1
xaddcarry256[60] A[60] B[60] CARRY0[59] VSS VSS VCC VCC CARRY0[60] S0[60] sky130_fd_sc_hd__fah_1
xaddcarry256[59] A[59] B[59] CARRY0[58] VSS VSS VCC VCC CARRY0[59] S0[59] sky130_fd_sc_hd__fah_1
xaddcarry256[58] A[58] B[58] CARRY0[57] VSS VSS VCC VCC CARRY0[58] S0[58] sky130_fd_sc_hd__fah_1
xaddcarry256[57] A[57] B[57] CARRY0[56] VSS VSS VCC VCC CARRY0[57] S0[57] sky130_fd_sc_hd__fah_1
xaddcarry256[56] A[56] B[56] CARRY0[55] VSS VSS VCC VCC CARRY0[56] S0[56] sky130_fd_sc_hd__fah_1
xaddcarry256[55] A[55] B[55] CARRY0[54] VSS VSS VCC VCC CARRY0[55] S0[55] sky130_fd_sc_hd__fah_1
xaddcarry256[54] A[54] B[54] CARRY0[53] VSS VSS VCC VCC CARRY0[54] S0[54] sky130_fd_sc_hd__fah_1
xaddcarry256[53] A[53] B[53] CARRY0[52] VSS VSS VCC VCC CARRY0[53] S0[53] sky130_fd_sc_hd__fah_1
xaddcarry256[52] A[52] B[52] CARRY0[51] VSS VSS VCC VCC CARRY0[52] S0[52] sky130_fd_sc_hd__fah_1
xaddcarry256[51] A[51] B[51] CARRY0[50] VSS VSS VCC VCC CARRY0[51] S0[51] sky130_fd_sc_hd__fah_1
xaddcarry256[50] A[50] B[50] CARRY0[49] VSS VSS VCC VCC CARRY0[50] S0[50] sky130_fd_sc_hd__fah_1
xaddcarry256[49] A[49] B[49] CARRY0[48] VSS VSS VCC VCC CARRY0[49] S0[49] sky130_fd_sc_hd__fah_1
xaddcarry256[48] A[48] B[48] CARRY0[47] VSS VSS VCC VCC CARRY0[48] S0[48] sky130_fd_sc_hd__fah_1
xaddcarry256[47] A[47] B[47] CARRY0[46] VSS VSS VCC VCC CARRY0[47] S0[47] sky130_fd_sc_hd__fah_1
xaddcarry256[46] A[46] B[46] CARRY0[45] VSS VSS VCC VCC CARRY0[46] S0[46] sky130_fd_sc_hd__fah_1
xaddcarry256[45] A[45] B[45] CARRY0[44] VSS VSS VCC VCC CARRY0[45] S0[45] sky130_fd_sc_hd__fah_1
xaddcarry256[44] A[44] B[44] CARRY0[43] VSS VSS VCC VCC CARRY0[44] S0[44] sky130_fd_sc_hd__fah_1
xaddcarry256[43] A[43] B[43] CARRY0[42] VSS VSS VCC VCC CARRY0[43] S0[43] sky130_fd_sc_hd__fah_1
xaddcarry256[42] A[42] B[42] CARRY0[41] VSS VSS VCC VCC CARRY0[42] S0[42] sky130_fd_sc_hd__fah_1
xaddcarry256[41] A[41] B[41] CARRY0[40] VSS VSS VCC VCC CARRY0[41] S0[41] sky130_fd_sc_hd__fah_1
xaddcarry256[40] A[40] B[40] CARRY0[39] VSS VSS VCC VCC CARRY0[40] S0[40] sky130_fd_sc_hd__fah_1
xaddcarry256[39] A[39] B[39] CARRY0[38] VSS VSS VCC VCC CARRY0[39] S0[39] sky130_fd_sc_hd__fah_1
xaddcarry256[38] A[38] B[38] CARRY0[37] VSS VSS VCC VCC CARRY0[38] S0[38] sky130_fd_sc_hd__fah_1
xaddcarry256[37] A[37] B[37] CARRY0[36] VSS VSS VCC VCC CARRY0[37] S0[37] sky130_fd_sc_hd__fah_1
xaddcarry256[36] A[36] B[36] CARRY0[35] VSS VSS VCC VCC CARRY0[36] S0[36] sky130_fd_sc_hd__fah_1
xaddcarry256[35] A[35] B[35] CARRY0[34] VSS VSS VCC VCC CARRY0[35] S0[35] sky130_fd_sc_hd__fah_1
xaddcarry256[34] A[34] B[34] CARRY0[33] VSS VSS VCC VCC CARRY0[34] S0[34] sky130_fd_sc_hd__fah_1
xaddcarry256[33] A[33] B[33] CARRY0[32] VSS VSS VCC VCC CARRY0[33] S0[33] sky130_fd_sc_hd__fah_1
xaddcarry256[32] A[32] B[32] CARRY0[31] VSS VSS VCC VCC CARRY0[32] S0[32] sky130_fd_sc_hd__fah_1
xaddcarry256[31] A[31] B[31] CARRY0[30] VSS VSS VCC VCC CARRY0[31] S0[31] sky130_fd_sc_hd__fah_1
xaddcarry256[30] A[30] B[30] CARRY0[29] VSS VSS VCC VCC CARRY0[30] S0[30] sky130_fd_sc_hd__fah_1
xaddcarry256[29] A[29] B[29] CARRY0[28] VSS VSS VCC VCC CARRY0[29] S0[29] sky130_fd_sc_hd__fah_1
xaddcarry256[28] A[28] B[28] CARRY0[27] VSS VSS VCC VCC CARRY0[28] S0[28] sky130_fd_sc_hd__fah_1
xaddcarry256[27] A[27] B[27] CARRY0[26] VSS VSS VCC VCC CARRY0[27] S0[27] sky130_fd_sc_hd__fah_1
xaddcarry256[26] A[26] B[26] CARRY0[25] VSS VSS VCC VCC CARRY0[26] S0[26] sky130_fd_sc_hd__fah_1
xaddcarry256[25] A[25] B[25] CARRY0[24] VSS VSS VCC VCC CARRY0[25] S0[25] sky130_fd_sc_hd__fah_1
xaddcarry256[24] A[24] B[24] CARRY0[23] VSS VSS VCC VCC CARRY0[24] S0[24] sky130_fd_sc_hd__fah_1
xaddcarry256[23] A[23] B[23] CARRY0[22] VSS VSS VCC VCC CARRY0[23] S0[23] sky130_fd_sc_hd__fah_1
xaddcarry256[22] A[22] B[22] CARRY0[21] VSS VSS VCC VCC CARRY0[22] S0[22] sky130_fd_sc_hd__fah_1
xaddcarry256[21] A[21] B[21] CARRY0[20] VSS VSS VCC VCC CARRY0[21] S0[21] sky130_fd_sc_hd__fah_1
xaddcarry256[20] A[20] B[20] CARRY0[19] VSS VSS VCC VCC CARRY0[20] S0[20] sky130_fd_sc_hd__fah_1
xaddcarry256[19] A[19] B[19] CARRY0[18] VSS VSS VCC VCC CARRY0[19] S0[19] sky130_fd_sc_hd__fah_1
xaddcarry256[18] A[18] B[18] CARRY0[17] VSS VSS VCC VCC CARRY0[18] S0[18] sky130_fd_sc_hd__fah_1
xaddcarry256[17] A[17] B[17] CARRY0[16] VSS VSS VCC VCC CARRY0[17] S0[17] sky130_fd_sc_hd__fah_1
xaddcarry256[16] A[16] B[16] CARRY0[15] VSS VSS VCC VCC CARRY0[16] S0[16] sky130_fd_sc_hd__fah_1
xaddcarry256[15] A[15] B[15] CARRY0[14] VSS VSS VCC VCC CARRY0[15] S0[15] sky130_fd_sc_hd__fah_1
xaddcarry256[14] A[14] B[14] CARRY0[13] VSS VSS VCC VCC CARRY0[14] S0[14] sky130_fd_sc_hd__fah_1
xaddcarry256[13] A[13] B[13] CARRY0[12] VSS VSS VCC VCC CARRY0[13] S0[13] sky130_fd_sc_hd__fah_1
xaddcarry256[12] A[12] B[12] CARRY0[11] VSS VSS VCC VCC CARRY0[12] S0[12] sky130_fd_sc_hd__fah_1
xaddcarry256[11] A[11] B[11] CARRY0[10] VSS VSS VCC VCC CARRY0[11] S0[11] sky130_fd_sc_hd__fah_1
xaddcarry256[10] A[10] B[10] CARRY0[9] VSS VSS VCC VCC CARRY0[10] S0[10] sky130_fd_sc_hd__fah_1
xaddcarry256[9] A[9] B[9] CARRY0[8] VSS VSS VCC VCC CARRY0[9] S0[9] sky130_fd_sc_hd__fah_1
xaddcarry256[8] A[8] B[8] CARRY0[7] VSS VSS VCC VCC CARRY0[8] S0[8] sky130_fd_sc_hd__fah_1
xaddcarry256[7] A[7] B[7] CARRY0[6] VSS VSS VCC VCC CARRY0[7] S0[7] sky130_fd_sc_hd__fah_1
xaddcarry256[6] A[6] B[6] CARRY0[5] VSS VSS VCC VCC CARRY0[6] S0[6] sky130_fd_sc_hd__fah_1
xaddcarry256[5] A[5] B[5] CARRY0[4] VSS VSS VCC VCC CARRY0[5] S0[5] sky130_fd_sc_hd__fah_1
xaddcarry256[4] A[4] B[4] CARRY0[3] VSS VSS VCC VCC CARRY0[4] S0[4] sky130_fd_sc_hd__fah_1
xaddcarry256[3] A[3] B[3] CARRY0[2] VSS VSS VCC VCC CARRY0[3] S0[3] sky130_fd_sc_hd__fah_1
xaddcarry256[2] A[2] B[2] CARRY0[1] VSS VSS VCC VCC CARRY0[2] S0[2] sky130_fd_sc_hd__fah_1
xaddcarry256[1] A[1] B[1] CARRY0[0] VSS VSS VCC VCC CARRY0[1] S0[1] sky130_fd_sc_hd__fah_1
xaddcarry256[0] A[0] B[0] CIN VSS VSS VCC VCC CARRY0[0] S0[0] sky130_fd_sc_hd__fah_1
xadd256 A[255] A[254] A[253] A[252] A[251] A[250] A[249] A[248] A[247] A[246] A[245] A[244] A[243] A[242] A[241] A[240] A[239]
+ A[238] A[237] A[236] A[235] A[234] A[233] A[232] A[231] A[230] A[229] A[228] A[227] A[226] A[225] A[224] A[223] A[222] A[221] A[220]
+ A[219] A[218] A[217] A[216] A[215] A[214] A[213] A[212] A[211] A[210] A[209] A[208] A[207] A[206] A[205] A[204] A[203] A[202] A[201]
+ A[200] A[199] A[198] A[197] A[196] A[195] A[194] A[193] A[192] A[191] A[190] A[189] A[188] A[187] A[186] A[185] A[184] A[183] A[182]
+ A[181] A[180] A[179] A[178] A[177] A[176] A[175] A[174] A[173] A[172] A[171] A[170] A[169] A[168] A[167] A[166] A[165] A[164] A[163]
+ A[162] A[161] A[160] A[159] A[158] A[157] A[156] A[155] A[154] A[153] A[152] A[151] A[150] A[149] A[148] A[147] A[146] A[145] A[144]
+ A[143] A[142] A[141] A[140] A[139] A[138] A[137] A[136] A[135] A[134] A[133] A[132] A[131] A[130] A[129] A[128] A[127] A[126] A[125]
+ A[124] A[123] A[122] A[121] A[120] A[119] A[118] A[117] A[116] A[115] A[114] A[113] A[112] A[111] A[110] A[109] A[108] A[107] A[106]
+ A[105] A[104] A[103] A[102] A[101] A[100] A[99] A[98] A[97] A[96] A[95] A[94] A[93] A[92] A[91] A[90] A[89] A[88] A[87] A[86] A[85]
+ A[84] A[83] A[82] A[81] A[80] A[79] A[78] A[77] A[76] A[75] A[74] A[73] A[72] A[71] A[70] A[69] A[68] A[67] A[66] A[65] A[64] A[63]
+ A[62] A[61] A[60] A[59] A[58] A[57] A[56] A[55] A[54] A[53] A[52] A[51] A[50] A[49] A[48] A[47] A[46] A[45] A[44] A[43] A[42] A[41]
+ A[40] A[39] A[38] A[37] A[36] A[35] A[34] A[33] A[32] A[31] A[30] A[29] A[28] A[27] A[26] A[25] A[24] A[23] A[22] A[21] A[20] A[19]
+ A[18] A[17] A[16] A[15] A[14] A[13] A[12] A[11] A[10] A[9] A[8] A[7] A[6] A[5] A[4] A[3] A[2] A[1] A[0] S3[255] S3[254] S3[253] S3[252]
+ S3[251] S3[250] S3[249] S3[248] S3[247] S3[246] S3[245] S3[244] S3[243] S3[242] S3[241] S3[240] S3[239] S3[238] S3[237] S3[236] S3[235]
+ S3[234] S3[233] S3[232] S3[231] S3[230] S3[229] S3[228] S3[227] S3[226] S3[225] S3[224] S3[223] S3[222] S3[221] S3[220] S3[219] S3[218]
+ S3[217] S3[216] S3[215] S3[214] S3[213] S3[212] S3[211] S3[210] S3[209] S3[208] S3[207] S3[206] S3[205] S3[204] S3[203] S3[202] S3[201]
+ S3[200] S3[199] S3[198] S3[197] S3[196] S3[195] S3[194] S3[193] S3[192] S3[191] S3[190] S3[189] S3[188] S3[187] S3[186] S3[185] S3[184]
+ S3[183] S3[182] S3[181] S3[180] S3[179] S3[178] S3[177] S3[176] S3[175] S3[174] S3[173] S3[172] S3[171] S3[170] S3[169] S3[168] S3[167]
+ S3[166] S3[165] S3[164] S3[163] S3[162] S3[161] S3[160] S3[159] S3[158] S3[157] S3[156] S3[155] S3[154] S3[153] S3[152] S3[151] S3[150]
+ S3[149] S3[148] S3[147] S3[146] S3[145] S3[144] S3[143] S3[142] S3[141] S3[140] S3[139] S3[138] S3[137] S3[136] S3[135] S3[134] S3[133]
+ S3[132] S3[131] S3[130] S3[129] S3[128] S3[127] S3[126] S3[125] S3[124] S3[123] S3[122] S3[121] S3[120] S3[119] S3[118] S3[117] S3[116]
+ S3[115] S3[114] S3[113] S3[112] S3[111] S3[110] S3[109] S3[108] S3[107] S3[106] S3[105] S3[104] S3[103] S3[102] S3[101] S3[100] S3[99]
+ S3[98] S3[97] S3[96] S3[95] S3[94] S3[93] S3[92] S3[91] S3[90] S3[89] S3[88] S3[87] S3[86] S3[85] S3[84] S3[83] S3[82] S3[81] S3[80]
+ S3[79] S3[78] S3[77] S3[76] S3[75] S3[74] S3[73] S3[72] S3[71] S3[70] S3[69] S3[68] S3[67] S3[66] S3[65] S3[64] S3[63] S3[62] S3[61]
+ S3[60] S3[59] S3[58] S3[57] S3[56] S3[55] S3[54] S3[53] S3[52] S3[51] S3[50] S3[49] S3[48] S3[47] S3[46] S3[45] S3[44] S3[43] S3[42]
+ S3[41] S3[40] S3[39] S3[38] S3[37] S3[36] S3[35] S3[34] S3[33] S3[32] S3[31] S3[30] S3[29] S3[28] S3[27] S3[26] S3[25] S3[24] S3[23]
+ S3[22] S3[21] S3[20] S3[19] S3[18] S3[17] S3[16] S3[15] S3[14] S3[13] S3[12] S3[11] S3[10] S3[9] S3[8] S3[7] S3[6] S3[5] S3[4] S3[3]
+ S3[2] S3[1] S3[0] B[255] B[254] B[253] B[252] B[251] B[250] B[249] B[248] B[247] B[246] B[245] B[244] B[243] B[242] B[241] B[240]
+ B[239] B[238] B[237] B[236] B[235] B[234] B[233] B[232] B[231] B[230] B[229] B[228] B[227] B[226] B[225] B[224] B[223] B[222] B[221]
+ B[220] B[219] B[218] B[217] B[216] B[215] B[214] B[213] B[212] B[211] B[210] B[209] B[208] B[207] B[206] B[205] B[204] B[203] B[202]
+ B[201] B[200] B[199] B[198] B[197] B[196] B[195] B[194] B[193] B[192] B[191] B[190] B[189] B[188] B[187] B[186] B[185] B[184] B[183]
+ B[182] B[181] B[180] B[179] B[178] B[177] B[176] B[175] B[174] B[173] B[172] B[171] B[170] B[169] B[168] B[167] B[166] B[165] B[164]
+ B[163] B[162] B[161] B[160] B[159] B[158] B[157] B[156] B[155] B[154] B[153] B[152] B[151] B[150] B[149] B[148] B[147] B[146] B[145]
+ B[144] B[143] B[142] B[141] B[140] B[139] B[138] B[137] B[136] B[135] B[134] B[133] B[132] B[131] B[130] B[129] B[128] B[127] B[126]
+ B[125] B[124] B[123] B[122] B[121] B[120] B[119] B[118] B[117] B[116] B[115] B[114] B[113] B[112] B[111] B[110] B[109] B[108] B[107]
+ B[106] B[105] B[104] B[103] B[102] B[101] B[100] B[99] B[98] B[97] B[96] B[95] B[94] B[93] B[92] B[91] B[90] B[89] B[88] B[87] B[86]
+ B[85] B[84] B[83] B[82] B[81] B[80] B[79] B[78] B[77] B[76] B[75] B[74] B[73] B[72] B[71] B[70] B[69] B[68] B[67] B[66] B[65] B[64]
+ B[63] B[62] B[61] B[60] B[59] B[58] B[57] B[56] B[55] B[54] B[53] B[52] B[51] B[50] B[49] B[48] B[47] B[46] B[45] B[44] B[43] B[42]
+ B[41] B[40] B[39] B[38] B[37] B[36] B[35] B[34] B[33] B[32] B[31] B[30] B[29] B[28] B[27] B[26] B[25] B[24] B[23] B[22] B[21] B[20]
+ B[19] B[18] B[17] B[16] B[15] B[14] B[13] B[12] B[11] B[10] B[9] B[8] B[7] B[6] B[5] B[4] B[3] B[2] B[1] B[0] COUT3 SG3 CIN SP3
+ adder_256bit
* noconn VCC
* noconn VSS
.save v(a[255])
.save v(a[254])
.save v(a[253])
.save v(a[252])
.save v(a[251])
.save v(a[250])
.save v(a[249])
.save v(a[248])
.save v(a[247])
.save v(a[246])
.save v(a[245])
.save v(a[244])
.save v(a[243])
.save v(a[242])
.save v(a[241])
.save v(a[240])
.save v(a[239])
.save v(a[238])
.save v(a[237])
.save v(a[236])
.save v(a[235])
.save v(a[234])
.save v(a[233])
.save v(a[232])
.save v(a[231])
.save v(a[230])
.save v(a[229])
.save v(a[228])
.save v(a[227])
.save v(a[226])
.save v(a[225])
.save v(a[224])
.save v(a[223])
.save v(a[222])
.save v(a[221])
.save v(a[220])
.save v(a[219])
.save v(a[218])
.save v(a[217])
.save v(a[216])
.save v(a[215])
.save v(a[214])
.save v(a[213])
.save v(a[212])
.save v(a[211])
.save v(a[210])
.save v(a[209])
.save v(a[208])
.save v(a[207])
.save v(a[206])
.save v(a[205])
.save v(a[204])
.save v(a[203])
.save v(a[202])
.save v(a[201])
.save v(a[200])
.save v(a[199])
.save v(a[198])
.save v(a[197])
.save v(a[196])
.save v(a[195])
.save v(a[194])
.save v(a[193])
.save v(a[192])
.save v(a[191])
.save v(a[190])
.save v(a[189])
.save v(a[188])
.save v(a[187])
.save v(a[186])
.save v(a[185])
.save v(a[184])
.save v(a[183])
.save v(a[182])
.save v(a[181])
.save v(a[180])
.save v(a[179])
.save v(a[178])
.save v(a[177])
.save v(a[176])
.save v(a[175])
.save v(a[174])
.save v(a[173])
.save v(a[172])
.save v(a[171])
.save v(a[170])
.save v(a[169])
.save v(a[168])
.save v(a[167])
.save v(a[166])
.save v(a[165])
.save v(a[164])
.save v(a[163])
.save v(a[162])
.save v(a[161])
.save v(a[160])
.save v(a[159])
.save v(a[158])
.save v(a[157])
.save v(a[156])
.save v(a[155])
.save v(a[154])
.save v(a[153])
.save v(a[152])
.save v(a[151])
.save v(a[150])
.save v(a[149])
.save v(a[148])
.save v(a[147])
.save v(a[146])
.save v(a[145])
.save v(a[144])
.save v(a[143])
.save v(a[142])
.save v(a[141])
.save v(a[140])
.save v(a[139])
.save v(a[138])
.save v(a[137])
.save v(a[136])
.save v(a[135])
.save v(a[134])
.save v(a[133])
.save v(a[132])
.save v(a[131])
.save v(a[130])
.save v(a[129])
.save v(a[128])
.save v(a[127])
.save v(a[126])
.save v(a[125])
.save v(a[124])
.save v(a[123])
.save v(a[122])
.save v(a[121])
.save v(a[120])
.save v(a[119])
.save v(a[118])
.save v(a[117])
.save v(a[116])
.save v(a[115])
.save v(a[114])
.save v(a[113])
.save v(a[112])
.save v(a[111])
.save v(a[110])
.save v(a[109])
.save v(a[108])
.save v(a[107])
.save v(a[106])
.save v(a[105])
.save v(a[104])
.save v(a[103])
.save v(a[102])
.save v(a[101])
.save v(a[100])
.save v(a[99])
.save v(a[98])
.save v(a[97])
.save v(a[96])
.save v(a[95])
.save v(a[94])
.save v(a[93])
.save v(a[92])
.save v(a[91])
.save v(a[90])
.save v(a[89])
.save v(a[88])
.save v(a[87])
.save v(a[86])
.save v(a[85])
.save v(a[84])
.save v(a[83])
.save v(a[82])
.save v(a[81])
.save v(a[80])
.save v(a[79])
.save v(a[78])
.save v(a[77])
.save v(a[76])
.save v(a[75])
.save v(a[74])
.save v(a[73])
.save v(a[72])
.save v(a[71])
.save v(a[70])
.save v(a[69])
.save v(a[68])
.save v(a[67])
.save v(a[66])
.save v(a[65])
.save v(a[64])
.save v(a[63])
.save v(a[62])
.save v(a[61])
.save v(a[60])
.save v(a[59])
.save v(a[58])
.save v(a[57])
.save v(a[56])
.save v(a[55])
.save v(a[54])
.save v(a[53])
.save v(a[52])
.save v(a[51])
.save v(a[50])
.save v(a[49])
.save v(a[48])
.save v(a[47])
.save v(a[46])
.save v(a[45])
.save v(a[44])
.save v(a[43])
.save v(a[42])
.save v(a[41])
.save v(a[40])
.save v(a[39])
.save v(a[38])
.save v(a[37])
.save v(a[36])
.save v(a[35])
.save v(a[34])
.save v(a[33])
.save v(a[32])
.save v(a[31])
.save v(a[30])
.save v(a[29])
.save v(a[28])
.save v(a[27])
.save v(a[26])
.save v(a[25])
.save v(a[24])
.save v(a[23])
.save v(a[22])
.save v(a[21])
.save v(a[20])
.save v(a[19])
.save v(a[18])
.save v(a[17])
.save v(a[16])
.save v(a[15])
.save v(a[14])
.save v(a[13])
.save v(a[12])
.save v(a[11])
.save v(a[10])
.save v(a[9])
.save v(a[8])
.save v(a[7])
.save v(a[6])
.save v(a[5])
.save v(a[4])
.save v(a[3])
.save v(a[2])
.save v(a[1])
.save v(a[0])
.save v(b[255])
.save v(b[254])
.save v(b[253])
.save v(b[252])
.save v(b[251])
.save v(b[250])
.save v(b[249])
.save v(b[248])
.save v(b[247])
.save v(b[246])
.save v(b[245])
.save v(b[244])
.save v(b[243])
.save v(b[242])
.save v(b[241])
.save v(b[240])
.save v(b[239])
.save v(b[238])
.save v(b[237])
.save v(b[236])
.save v(b[235])
.save v(b[234])
.save v(b[233])
.save v(b[232])
.save v(b[231])
.save v(b[230])
.save v(b[229])
.save v(b[228])
.save v(b[227])
.save v(b[226])
.save v(b[225])
.save v(b[224])
.save v(b[223])
.save v(b[222])
.save v(b[221])
.save v(b[220])
.save v(b[219])
.save v(b[218])
.save v(b[217])
.save v(b[216])
.save v(b[215])
.save v(b[214])
.save v(b[213])
.save v(b[212])
.save v(b[211])
.save v(b[210])
.save v(b[209])
.save v(b[208])
.save v(b[207])
.save v(b[206])
.save v(b[205])
.save v(b[204])
.save v(b[203])
.save v(b[202])
.save v(b[201])
.save v(b[200])
.save v(b[199])
.save v(b[198])
.save v(b[197])
.save v(b[196])
.save v(b[195])
.save v(b[194])
.save v(b[193])
.save v(b[192])
.save v(b[191])
.save v(b[190])
.save v(b[189])
.save v(b[188])
.save v(b[187])
.save v(b[186])
.save v(b[185])
.save v(b[184])
.save v(b[183])
.save v(b[182])
.save v(b[181])
.save v(b[180])
.save v(b[179])
.save v(b[178])
.save v(b[177])
.save v(b[176])
.save v(b[175])
.save v(b[174])
.save v(b[173])
.save v(b[172])
.save v(b[171])
.save v(b[170])
.save v(b[169])
.save v(b[168])
.save v(b[167])
.save v(b[166])
.save v(b[165])
.save v(b[164])
.save v(b[163])
.save v(b[162])
.save v(b[161])
.save v(b[160])
.save v(b[159])
.save v(b[158])
.save v(b[157])
.save v(b[156])
.save v(b[155])
.save v(b[154])
.save v(b[153])
.save v(b[152])
.save v(b[151])
.save v(b[150])
.save v(b[149])
.save v(b[148])
.save v(b[147])
.save v(b[146])
.save v(b[145])
.save v(b[144])
.save v(b[143])
.save v(b[142])
.save v(b[141])
.save v(b[140])
.save v(b[139])
.save v(b[138])
.save v(b[137])
.save v(b[136])
.save v(b[135])
.save v(b[134])
.save v(b[133])
.save v(b[132])
.save v(b[131])
.save v(b[130])
.save v(b[129])
.save v(b[128])
.save v(b[127])
.save v(b[126])
.save v(b[125])
.save v(b[124])
.save v(b[123])
.save v(b[122])
.save v(b[121])
.save v(b[120])
.save v(b[119])
.save v(b[118])
.save v(b[117])
.save v(b[116])
.save v(b[115])
.save v(b[114])
.save v(b[113])
.save v(b[112])
.save v(b[111])
.save v(b[110])
.save v(b[109])
.save v(b[108])
.save v(b[107])
.save v(b[106])
.save v(b[105])
.save v(b[104])
.save v(b[103])
.save v(b[102])
.save v(b[101])
.save v(b[100])
.save v(b[99])
.save v(b[98])
.save v(b[97])
.save v(b[96])
.save v(b[95])
.save v(b[94])
.save v(b[93])
.save v(b[92])
.save v(b[91])
.save v(b[90])
.save v(b[89])
.save v(b[88])
.save v(b[87])
.save v(b[86])
.save v(b[85])
.save v(b[84])
.save v(b[83])
.save v(b[82])
.save v(b[81])
.save v(b[80])
.save v(b[79])
.save v(b[78])
.save v(b[77])
.save v(b[76])
.save v(b[75])
.save v(b[74])
.save v(b[73])
.save v(b[72])
.save v(b[71])
.save v(b[70])
.save v(b[69])
.save v(b[68])
.save v(b[67])
.save v(b[66])
.save v(b[65])
.save v(b[64])
.save v(b[63])
.save v(b[62])
.save v(b[61])
.save v(b[60])
.save v(b[59])
.save v(b[58])
.save v(b[57])
.save v(b[56])
.save v(b[55])
.save v(b[54])
.save v(b[53])
.save v(b[52])
.save v(b[51])
.save v(b[50])
.save v(b[49])
.save v(b[48])
.save v(b[47])
.save v(b[46])
.save v(b[45])
.save v(b[44])
.save v(b[43])
.save v(b[42])
.save v(b[41])
.save v(b[40])
.save v(b[39])
.save v(b[38])
.save v(b[37])
.save v(b[36])
.save v(b[35])
.save v(b[34])
.save v(b[33])
.save v(b[32])
.save v(b[31])
.save v(b[30])
.save v(b[29])
.save v(b[28])
.save v(b[27])
.save v(b[26])
.save v(b[25])
.save v(b[24])
.save v(b[23])
.save v(b[22])
.save v(b[21])
.save v(b[20])
.save v(b[19])
.save v(b[18])
.save v(b[17])
.save v(b[16])
.save v(b[15])
.save v(b[14])
.save v(b[13])
.save v(b[12])
.save v(b[11])
.save v(b[10])
.save v(b[9])
.save v(b[8])
.save v(b[7])
.save v(b[6])
.save v(b[5])
.save v(b[4])
.save v(b[3])
.save v(b[2])
.save v(b[1])
.save v(b[0])
.save v(cin)
.save v(s3[255])
.save v(s3[254])
.save v(s3[253])
.save v(s3[252])
.save v(s3[251])
.save v(s3[250])
.save v(s3[249])
.save v(s3[248])
.save v(s3[247])
.save v(s3[246])
.save v(s3[245])
.save v(s3[244])
.save v(s3[243])
.save v(s3[242])
.save v(s3[241])
.save v(s3[240])
.save v(s3[239])
.save v(s3[238])
.save v(s3[237])
.save v(s3[236])
.save v(s3[235])
.save v(s3[234])
.save v(s3[233])
.save v(s3[232])
.save v(s3[231])
.save v(s3[230])
.save v(s3[229])
.save v(s3[228])
.save v(s3[227])
.save v(s3[226])
.save v(s3[225])
.save v(s3[224])
.save v(s3[223])
.save v(s3[222])
.save v(s3[221])
.save v(s3[220])
.save v(s3[219])
.save v(s3[218])
.save v(s3[217])
.save v(s3[216])
.save v(s3[215])
.save v(s3[214])
.save v(s3[213])
.save v(s3[212])
.save v(s3[211])
.save v(s3[210])
.save v(s3[209])
.save v(s3[208])
.save v(s3[207])
.save v(s3[206])
.save v(s3[205])
.save v(s3[204])
.save v(s3[203])
.save v(s3[202])
.save v(s3[201])
.save v(s3[200])
.save v(s3[199])
.save v(s3[198])
.save v(s3[197])
.save v(s3[196])
.save v(s3[195])
.save v(s3[194])
.save v(s3[193])
.save v(s3[192])
.save v(s3[191])
.save v(s3[190])
.save v(s3[189])
.save v(s3[188])
.save v(s3[187])
.save v(s3[186])
.save v(s3[185])
.save v(s3[184])
.save v(s3[183])
.save v(s3[182])
.save v(s3[181])
.save v(s3[180])
.save v(s3[179])
.save v(s3[178])
.save v(s3[177])
.save v(s3[176])
.save v(s3[175])
.save v(s3[174])
.save v(s3[173])
.save v(s3[172])
.save v(s3[171])
.save v(s3[170])
.save v(s3[169])
.save v(s3[168])
.save v(s3[167])
.save v(s3[166])
.save v(s3[165])
.save v(s3[164])
.save v(s3[163])
.save v(s3[162])
.save v(s3[161])
.save v(s3[160])
.save v(s3[159])
.save v(s3[158])
.save v(s3[157])
.save v(s3[156])
.save v(s3[155])
.save v(s3[154])
.save v(s3[153])
.save v(s3[152])
.save v(s3[151])
.save v(s3[150])
.save v(s3[149])
.save v(s3[148])
.save v(s3[147])
.save v(s3[146])
.save v(s3[145])
.save v(s3[144])
.save v(s3[143])
.save v(s3[142])
.save v(s3[141])
.save v(s3[140])
.save v(s3[139])
.save v(s3[138])
.save v(s3[137])
.save v(s3[136])
.save v(s3[135])
.save v(s3[134])
.save v(s3[133])
.save v(s3[132])
.save v(s3[131])
.save v(s3[130])
.save v(s3[129])
.save v(s3[128])
.save v(s3[127])
.save v(s3[126])
.save v(s3[125])
.save v(s3[124])
.save v(s3[123])
.save v(s3[122])
.save v(s3[121])
.save v(s3[120])
.save v(s3[119])
.save v(s3[118])
.save v(s3[117])
.save v(s3[116])
.save v(s3[115])
.save v(s3[114])
.save v(s3[113])
.save v(s3[112])
.save v(s3[111])
.save v(s3[110])
.save v(s3[109])
.save v(s3[108])
.save v(s3[107])
.save v(s3[106])
.save v(s3[105])
.save v(s3[104])
.save v(s3[103])
.save v(s3[102])
.save v(s3[101])
.save v(s3[100])
.save v(s3[99])
.save v(s3[98])
.save v(s3[97])
.save v(s3[96])
.save v(s3[95])
.save v(s3[94])
.save v(s3[93])
.save v(s3[92])
.save v(s3[91])
.save v(s3[90])
.save v(s3[89])
.save v(s3[88])
.save v(s3[87])
.save v(s3[86])
.save v(s3[85])
.save v(s3[84])
.save v(s3[83])
.save v(s3[82])
.save v(s3[81])
.save v(s3[80])
.save v(s3[79])
.save v(s3[78])
.save v(s3[77])
.save v(s3[76])
.save v(s3[75])
.save v(s3[74])
.save v(s3[73])
.save v(s3[72])
.save v(s3[71])
.save v(s3[70])
.save v(s3[69])
.save v(s3[68])
.save v(s3[67])
.save v(s3[66])
.save v(s3[65])
.save v(s3[64])
.save v(s3[63])
.save v(s3[62])
.save v(s3[61])
.save v(s3[60])
.save v(s3[59])
.save v(s3[58])
.save v(s3[57])
.save v(s3[56])
.save v(s3[55])
.save v(s3[54])
.save v(s3[53])
.save v(s3[52])
.save v(s3[51])
.save v(s3[50])
.save v(s3[49])
.save v(s3[48])
.save v(s3[47])
.save v(s3[46])
.save v(s3[45])
.save v(s3[44])
.save v(s3[43])
.save v(s3[42])
.save v(s3[41])
.save v(s3[40])
.save v(s3[39])
.save v(s3[38])
.save v(s3[37])
.save v(s3[36])
.save v(s3[35])
.save v(s3[34])
.save v(s3[33])
.save v(s3[32])
.save v(s3[31])
.save v(s3[30])
.save v(s3[29])
.save v(s3[28])
.save v(s3[27])
.save v(s3[26])
.save v(s3[25])
.save v(s3[24])
.save v(s3[23])
.save v(s3[22])
.save v(s3[21])
.save v(s3[20])
.save v(s3[19])
.save v(s3[18])
.save v(s3[17])
.save v(s3[16])
.save v(s3[15])
.save v(s3[14])
.save v(s3[13])
.save v(s3[12])
.save v(s3[11])
.save v(s3[10])
.save v(s3[9])
.save v(s3[8])
.save v(s3[7])
.save v(s3[6])
.save v(s3[5])
.save v(s3[4])
.save v(s3[3])
.save v(s3[2])
.save v(s3[1])
.save v(s3[0])
.save v(cout3)
.save v(carry0[255])
.save v(carry0[254])
.save v(carry0[253])
.save v(carry0[252])
.save v(carry0[251])
.save v(carry0[250])
.save v(carry0[249])
.save v(carry0[248])
.save v(carry0[247])
.save v(carry0[246])
.save v(carry0[245])
.save v(carry0[244])
.save v(carry0[243])
.save v(carry0[242])
.save v(carry0[241])
.save v(carry0[240])
.save v(carry0[239])
.save v(carry0[238])
.save v(carry0[237])
.save v(carry0[236])
.save v(carry0[235])
.save v(carry0[234])
.save v(carry0[233])
.save v(carry0[232])
.save v(carry0[231])
.save v(carry0[230])
.save v(carry0[229])
.save v(carry0[228])
.save v(carry0[227])
.save v(carry0[226])
.save v(carry0[225])
.save v(carry0[224])
.save v(carry0[223])
.save v(carry0[222])
.save v(carry0[221])
.save v(carry0[220])
.save v(carry0[219])
.save v(carry0[218])
.save v(carry0[217])
.save v(carry0[216])
.save v(carry0[215])
.save v(carry0[214])
.save v(carry0[213])
.save v(carry0[212])
.save v(carry0[211])
.save v(carry0[210])
.save v(carry0[209])
.save v(carry0[208])
.save v(carry0[207])
.save v(carry0[206])
.save v(carry0[205])
.save v(carry0[204])
.save v(carry0[203])
.save v(carry0[202])
.save v(carry0[201])
.save v(carry0[200])
.save v(carry0[199])
.save v(carry0[198])
.save v(carry0[197])
.save v(carry0[196])
.save v(carry0[195])
.save v(carry0[194])
.save v(carry0[193])
.save v(carry0[192])
.save v(carry0[191])
.save v(carry0[190])
.save v(carry0[189])
.save v(carry0[188])
.save v(carry0[187])
.save v(carry0[186])
.save v(carry0[185])
.save v(carry0[184])
.save v(carry0[183])
.save v(carry0[182])
.save v(carry0[181])
.save v(carry0[180])
.save v(carry0[179])
.save v(carry0[178])
.save v(carry0[177])
.save v(carry0[176])
.save v(carry0[175])
.save v(carry0[174])
.save v(carry0[173])
.save v(carry0[172])
.save v(carry0[171])
.save v(carry0[170])
.save v(carry0[169])
.save v(carry0[168])
.save v(carry0[167])
.save v(carry0[166])
.save v(carry0[165])
.save v(carry0[164])
.save v(carry0[163])
.save v(carry0[162])
.save v(carry0[161])
.save v(carry0[160])
.save v(carry0[159])
.save v(carry0[158])
.save v(carry0[157])
.save v(carry0[156])
.save v(carry0[155])
.save v(carry0[154])
.save v(carry0[153])
.save v(carry0[152])
.save v(carry0[151])
.save v(carry0[150])
.save v(carry0[149])
.save v(carry0[148])
.save v(carry0[147])
.save v(carry0[146])
.save v(carry0[145])
.save v(carry0[144])
.save v(carry0[143])
.save v(carry0[142])
.save v(carry0[141])
.save v(carry0[140])
.save v(carry0[139])
.save v(carry0[138])
.save v(carry0[137])
.save v(carry0[136])
.save v(carry0[135])
.save v(carry0[134])
.save v(carry0[133])
.save v(carry0[132])
.save v(carry0[131])
.save v(carry0[130])
.save v(carry0[129])
.save v(carry0[128])
.save v(carry0[127])
.save v(carry0[126])
.save v(carry0[125])
.save v(carry0[124])
.save v(carry0[123])
.save v(carry0[122])
.save v(carry0[121])
.save v(carry0[120])
.save v(carry0[119])
.save v(carry0[118])
.save v(carry0[117])
.save v(carry0[116])
.save v(carry0[115])
.save v(carry0[114])
.save v(carry0[113])
.save v(carry0[112])
.save v(carry0[111])
.save v(carry0[110])
.save v(carry0[109])
.save v(carry0[108])
.save v(carry0[107])
.save v(carry0[106])
.save v(carry0[105])
.save v(carry0[104])
.save v(carry0[103])
.save v(carry0[102])
.save v(carry0[101])
.save v(carry0[100])
.save v(carry0[99])
.save v(carry0[98])
.save v(carry0[97])
.save v(carry0[96])
.save v(carry0[95])
.save v(carry0[94])
.save v(carry0[93])
.save v(carry0[92])
.save v(carry0[91])
.save v(carry0[90])
.save v(carry0[89])
.save v(carry0[88])
.save v(carry0[87])
.save v(carry0[86])
.save v(carry0[85])
.save v(carry0[84])
.save v(carry0[83])
.save v(carry0[82])
.save v(carry0[81])
.save v(carry0[80])
.save v(carry0[79])
.save v(carry0[78])
.save v(carry0[77])
.save v(carry0[76])
.save v(carry0[75])
.save v(carry0[74])
.save v(carry0[73])
.save v(carry0[72])
.save v(carry0[71])
.save v(carry0[70])
.save v(carry0[69])
.save v(carry0[68])
.save v(carry0[67])
.save v(carry0[66])
.save v(carry0[65])
.save v(carry0[64])
.save v(carry0[63])
.save v(carry0[62])
.save v(carry0[61])
.save v(carry0[60])
.save v(carry0[59])
.save v(carry0[58])
.save v(carry0[57])
.save v(carry0[56])
.save v(carry0[55])
.save v(carry0[54])
.save v(carry0[53])
.save v(carry0[52])
.save v(carry0[51])
.save v(carry0[50])
.save v(carry0[49])
.save v(carry0[48])
.save v(carry0[47])
.save v(carry0[46])
.save v(carry0[45])
.save v(carry0[44])
.save v(carry0[43])
.save v(carry0[42])
.save v(carry0[41])
.save v(carry0[40])
.save v(carry0[39])
.save v(carry0[38])
.save v(carry0[37])
.save v(carry0[36])
.save v(carry0[35])
.save v(carry0[34])
.save v(carry0[33])
.save v(carry0[32])
.save v(carry0[31])
.save v(carry0[30])
.save v(carry0[29])
.save v(carry0[28])
.save v(carry0[27])
.save v(carry0[26])
.save v(carry0[25])
.save v(carry0[24])
.save v(carry0[23])
.save v(carry0[22])
.save v(carry0[21])
.save v(carry0[20])
.save v(carry0[19])
.save v(carry0[18])
.save v(carry0[17])
.save v(carry0[16])
.save v(carry0[15])
.save v(carry0[14])
.save v(carry0[13])
.save v(carry0[12])
.save v(carry0[11])
.save v(carry0[10])
.save v(carry0[9])
.save v(carry0[8])
.save v(carry0[7])
.save v(carry0[6])
.save v(carry0[5])
.save v(carry0[4])
.save v(carry0[3])
.save v(carry0[2])
.save v(carry0[1])
.save v(carry0[0])
.save v(s0[255])
.save v(s0[254])
.save v(s0[253])
.save v(s0[252])
.save v(s0[251])
.save v(s0[250])
.save v(s0[249])
.save v(s0[248])
.save v(s0[247])
.save v(s0[246])
.save v(s0[245])
.save v(s0[244])
.save v(s0[243])
.save v(s0[242])
.save v(s0[241])
.save v(s0[240])
.save v(s0[239])
.save v(s0[238])
.save v(s0[237])
.save v(s0[236])
.save v(s0[235])
.save v(s0[234])
.save v(s0[233])
.save v(s0[232])
.save v(s0[231])
.save v(s0[230])
.save v(s0[229])
.save v(s0[228])
.save v(s0[227])
.save v(s0[226])
.save v(s0[225])
.save v(s0[224])
.save v(s0[223])
.save v(s0[222])
.save v(s0[221])
.save v(s0[220])
.save v(s0[219])
.save v(s0[218])
.save v(s0[217])
.save v(s0[216])
.save v(s0[215])
.save v(s0[214])
.save v(s0[213])
.save v(s0[212])
.save v(s0[211])
.save v(s0[210])
.save v(s0[209])
.save v(s0[208])
.save v(s0[207])
.save v(s0[206])
.save v(s0[205])
.save v(s0[204])
.save v(s0[203])
.save v(s0[202])
.save v(s0[201])
.save v(s0[200])
.save v(s0[199])
.save v(s0[198])
.save v(s0[197])
.save v(s0[196])
.save v(s0[195])
.save v(s0[194])
.save v(s0[193])
.save v(s0[192])
.save v(s0[191])
.save v(s0[190])
.save v(s0[189])
.save v(s0[188])
.save v(s0[187])
.save v(s0[186])
.save v(s0[185])
.save v(s0[184])
.save v(s0[183])
.save v(s0[182])
.save v(s0[181])
.save v(s0[180])
.save v(s0[179])
.save v(s0[178])
.save v(s0[177])
.save v(s0[176])
.save v(s0[175])
.save v(s0[174])
.save v(s0[173])
.save v(s0[172])
.save v(s0[171])
.save v(s0[170])
.save v(s0[169])
.save v(s0[168])
.save v(s0[167])
.save v(s0[166])
.save v(s0[165])
.save v(s0[164])
.save v(s0[163])
.save v(s0[162])
.save v(s0[161])
.save v(s0[160])
.save v(s0[159])
.save v(s0[158])
.save v(s0[157])
.save v(s0[156])
.save v(s0[155])
.save v(s0[154])
.save v(s0[153])
.save v(s0[152])
.save v(s0[151])
.save v(s0[150])
.save v(s0[149])
.save v(s0[148])
.save v(s0[147])
.save v(s0[146])
.save v(s0[145])
.save v(s0[144])
.save v(s0[143])
.save v(s0[142])
.save v(s0[141])
.save v(s0[140])
.save v(s0[139])
.save v(s0[138])
.save v(s0[137])
.save v(s0[136])
.save v(s0[135])
.save v(s0[134])
.save v(s0[133])
.save v(s0[132])
.save v(s0[131])
.save v(s0[130])
.save v(s0[129])
.save v(s0[128])
.save v(s0[127])
.save v(s0[126])
.save v(s0[125])
.save v(s0[124])
.save v(s0[123])
.save v(s0[122])
.save v(s0[121])
.save v(s0[120])
.save v(s0[119])
.save v(s0[118])
.save v(s0[117])
.save v(s0[116])
.save v(s0[115])
.save v(s0[114])
.save v(s0[113])
.save v(s0[112])
.save v(s0[111])
.save v(s0[110])
.save v(s0[109])
.save v(s0[108])
.save v(s0[107])
.save v(s0[106])
.save v(s0[105])
.save v(s0[104])
.save v(s0[103])
.save v(s0[102])
.save v(s0[101])
.save v(s0[100])
.save v(s0[99])
.save v(s0[98])
.save v(s0[97])
.save v(s0[96])
.save v(s0[95])
.save v(s0[94])
.save v(s0[93])
.save v(s0[92])
.save v(s0[91])
.save v(s0[90])
.save v(s0[89])
.save v(s0[88])
.save v(s0[87])
.save v(s0[86])
.save v(s0[85])
.save v(s0[84])
.save v(s0[83])
.save v(s0[82])
.save v(s0[81])
.save v(s0[80])
.save v(s0[79])
.save v(s0[78])
.save v(s0[77])
.save v(s0[76])
.save v(s0[75])
.save v(s0[74])
.save v(s0[73])
.save v(s0[72])
.save v(s0[71])
.save v(s0[70])
.save v(s0[69])
.save v(s0[68])
.save v(s0[67])
.save v(s0[66])
.save v(s0[65])
.save v(s0[64])
.save v(s0[63])
.save v(s0[62])
.save v(s0[61])
.save v(s0[60])
.save v(s0[59])
.save v(s0[58])
.save v(s0[57])
.save v(s0[56])
.save v(s0[55])
.save v(s0[54])
.save v(s0[53])
.save v(s0[52])
.save v(s0[51])
.save v(s0[50])
.save v(s0[49])
.save v(s0[48])
.save v(s0[47])
.save v(s0[46])
.save v(s0[45])
.save v(s0[44])
.save v(s0[43])
.save v(s0[42])
.save v(s0[41])
.save v(s0[40])
.save v(s0[39])
.save v(s0[38])
.save v(s0[37])
.save v(s0[36])
.save v(s0[35])
.save v(s0[34])
.save v(s0[33])
.save v(s0[32])
.save v(s0[31])
.save v(s0[30])
.save v(s0[29])
.save v(s0[28])
.save v(s0[27])
.save v(s0[26])
.save v(s0[25])
.save v(s0[24])
.save v(s0[23])
.save v(s0[22])
.save v(s0[21])
.save v(s0[20])
.save v(s0[19])
.save v(s0[18])
.save v(s0[17])
.save v(s0[16])
.save v(s0[15])
.save v(s0[14])
.save v(s0[13])
.save v(s0[12])
.save v(s0[11])
.save v(s0[10])
.save v(s0[9])
.save v(s0[8])
.save v(s0[7])
.save v(s0[6])
.save v(s0[5])
.save v(s0[4])
.save v(s0[3])
.save v(s0[2])
.save v(s0[1])
.save v(s0[0])
.save v(vcc)
C7[255] S0[255] 0 5f
C7[254] S0[254] 0 5f
C7[253] S0[253] 0 5f
C7[252] S0[252] 0 5f
C7[251] S0[251] 0 5f
C7[250] S0[250] 0 5f
C7[249] S0[249] 0 5f
C7[248] S0[248] 0 5f
C7[247] S0[247] 0 5f
C7[246] S0[246] 0 5f
C7[245] S0[245] 0 5f
C7[244] S0[244] 0 5f
C7[243] S0[243] 0 5f
C7[242] S0[242] 0 5f
C7[241] S0[241] 0 5f
C7[240] S0[240] 0 5f
C7[239] S0[239] 0 5f
C7[238] S0[238] 0 5f
C7[237] S0[237] 0 5f
C7[236] S0[236] 0 5f
C7[235] S0[235] 0 5f
C7[234] S0[234] 0 5f
C7[233] S0[233] 0 5f
C7[232] S0[232] 0 5f
C7[231] S0[231] 0 5f
C7[230] S0[230] 0 5f
C7[229] S0[229] 0 5f
C7[228] S0[228] 0 5f
C7[227] S0[227] 0 5f
C7[226] S0[226] 0 5f
C7[225] S0[225] 0 5f
C7[224] S0[224] 0 5f
C7[223] S0[223] 0 5f
C7[222] S0[222] 0 5f
C7[221] S0[221] 0 5f
C7[220] S0[220] 0 5f
C7[219] S0[219] 0 5f
C7[218] S0[218] 0 5f
C7[217] S0[217] 0 5f
C7[216] S0[216] 0 5f
C7[215] S0[215] 0 5f
C7[214] S0[214] 0 5f
C7[213] S0[213] 0 5f
C7[212] S0[212] 0 5f
C7[211] S0[211] 0 5f
C7[210] S0[210] 0 5f
C7[209] S0[209] 0 5f
C7[208] S0[208] 0 5f
C7[207] S0[207] 0 5f
C7[206] S0[206] 0 5f
C7[205] S0[205] 0 5f
C7[204] S0[204] 0 5f
C7[203] S0[203] 0 5f
C7[202] S0[202] 0 5f
C7[201] S0[201] 0 5f
C7[200] S0[200] 0 5f
C7[199] S0[199] 0 5f
C7[198] S0[198] 0 5f
C7[197] S0[197] 0 5f
C7[196] S0[196] 0 5f
C7[195] S0[195] 0 5f
C7[194] S0[194] 0 5f
C7[193] S0[193] 0 5f
C7[192] S0[192] 0 5f
C7[191] S0[191] 0 5f
C7[190] S0[190] 0 5f
C7[189] S0[189] 0 5f
C7[188] S0[188] 0 5f
C7[187] S0[187] 0 5f
C7[186] S0[186] 0 5f
C7[185] S0[185] 0 5f
C7[184] S0[184] 0 5f
C7[183] S0[183] 0 5f
C7[182] S0[182] 0 5f
C7[181] S0[181] 0 5f
C7[180] S0[180] 0 5f
C7[179] S0[179] 0 5f
C7[178] S0[178] 0 5f
C7[177] S0[177] 0 5f
C7[176] S0[176] 0 5f
C7[175] S0[175] 0 5f
C7[174] S0[174] 0 5f
C7[173] S0[173] 0 5f
C7[172] S0[172] 0 5f
C7[171] S0[171] 0 5f
C7[170] S0[170] 0 5f
C7[169] S0[169] 0 5f
C7[168] S0[168] 0 5f
C7[167] S0[167] 0 5f
C7[166] S0[166] 0 5f
C7[165] S0[165] 0 5f
C7[164] S0[164] 0 5f
C7[163] S0[163] 0 5f
C7[162] S0[162] 0 5f
C7[161] S0[161] 0 5f
C7[160] S0[160] 0 5f
C7[159] S0[159] 0 5f
C7[158] S0[158] 0 5f
C7[157] S0[157] 0 5f
C7[156] S0[156] 0 5f
C7[155] S0[155] 0 5f
C7[154] S0[154] 0 5f
C7[153] S0[153] 0 5f
C7[152] S0[152] 0 5f
C7[151] S0[151] 0 5f
C7[150] S0[150] 0 5f
C7[149] S0[149] 0 5f
C7[148] S0[148] 0 5f
C7[147] S0[147] 0 5f
C7[146] S0[146] 0 5f
C7[145] S0[145] 0 5f
C7[144] S0[144] 0 5f
C7[143] S0[143] 0 5f
C7[142] S0[142] 0 5f
C7[141] S0[141] 0 5f
C7[140] S0[140] 0 5f
C7[139] S0[139] 0 5f
C7[138] S0[138] 0 5f
C7[137] S0[137] 0 5f
C7[136] S0[136] 0 5f
C7[135] S0[135] 0 5f
C7[134] S0[134] 0 5f
C7[133] S0[133] 0 5f
C7[132] S0[132] 0 5f
C7[131] S0[131] 0 5f
C7[130] S0[130] 0 5f
C7[129] S0[129] 0 5f
C7[128] S0[128] 0 5f
C7[127] S0[127] 0 5f
C7[126] S0[126] 0 5f
C7[125] S0[125] 0 5f
C7[124] S0[124] 0 5f
C7[123] S0[123] 0 5f
C7[122] S0[122] 0 5f
C7[121] S0[121] 0 5f
C7[120] S0[120] 0 5f
C7[119] S0[119] 0 5f
C7[118] S0[118] 0 5f
C7[117] S0[117] 0 5f
C7[116] S0[116] 0 5f
C7[115] S0[115] 0 5f
C7[114] S0[114] 0 5f
C7[113] S0[113] 0 5f
C7[112] S0[112] 0 5f
C7[111] S0[111] 0 5f
C7[110] S0[110] 0 5f
C7[109] S0[109] 0 5f
C7[108] S0[108] 0 5f
C7[107] S0[107] 0 5f
C7[106] S0[106] 0 5f
C7[105] S0[105] 0 5f
C7[104] S0[104] 0 5f
C7[103] S0[103] 0 5f
C7[102] S0[102] 0 5f
C7[101] S0[101] 0 5f
C7[100] S0[100] 0 5f
C7[99] S0[99] 0 5f
C7[98] S0[98] 0 5f
C7[97] S0[97] 0 5f
C7[96] S0[96] 0 5f
C7[95] S0[95] 0 5f
C7[94] S0[94] 0 5f
C7[93] S0[93] 0 5f
C7[92] S0[92] 0 5f
C7[91] S0[91] 0 5f
C7[90] S0[90] 0 5f
C7[89] S0[89] 0 5f
C7[88] S0[88] 0 5f
C7[87] S0[87] 0 5f
C7[86] S0[86] 0 5f
C7[85] S0[85] 0 5f
C7[84] S0[84] 0 5f
C7[83] S0[83] 0 5f
C7[82] S0[82] 0 5f
C7[81] S0[81] 0 5f
C7[80] S0[80] 0 5f
C7[79] S0[79] 0 5f
C7[78] S0[78] 0 5f
C7[77] S0[77] 0 5f
C7[76] S0[76] 0 5f
C7[75] S0[75] 0 5f
C7[74] S0[74] 0 5f
C7[73] S0[73] 0 5f
C7[72] S0[72] 0 5f
C7[71] S0[71] 0 5f
C7[70] S0[70] 0 5f
C7[69] S0[69] 0 5f
C7[68] S0[68] 0 5f
C7[67] S0[67] 0 5f
C7[66] S0[66] 0 5f
C7[65] S0[65] 0 5f
C7[64] S0[64] 0 5f
C7[63] S0[63] 0 5f
C7[62] S0[62] 0 5f
C7[61] S0[61] 0 5f
C7[60] S0[60] 0 5f
C7[59] S0[59] 0 5f
C7[58] S0[58] 0 5f
C7[57] S0[57] 0 5f
C7[56] S0[56] 0 5f
C7[55] S0[55] 0 5f
C7[54] S0[54] 0 5f
C7[53] S0[53] 0 5f
C7[52] S0[52] 0 5f
C7[51] S0[51] 0 5f
C7[50] S0[50] 0 5f
C7[49] S0[49] 0 5f
C7[48] S0[48] 0 5f
C7[47] S0[47] 0 5f
C7[46] S0[46] 0 5f
C7[45] S0[45] 0 5f
C7[44] S0[44] 0 5f
C7[43] S0[43] 0 5f
C7[42] S0[42] 0 5f
C7[41] S0[41] 0 5f
C7[40] S0[40] 0 5f
C7[39] S0[39] 0 5f
C7[38] S0[38] 0 5f
C7[37] S0[37] 0 5f
C7[36] S0[36] 0 5f
C7[35] S0[35] 0 5f
C7[34] S0[34] 0 5f
C7[33] S0[33] 0 5f
C7[32] S0[32] 0 5f
C7[31] S0[31] 0 5f
C7[30] S0[30] 0 5f
C7[29] S0[29] 0 5f
C7[28] S0[28] 0 5f
C7[27] S0[27] 0 5f
C7[26] S0[26] 0 5f
C7[25] S0[25] 0 5f
C7[24] S0[24] 0 5f
C7[23] S0[23] 0 5f
C7[22] S0[22] 0 5f
C7[21] S0[21] 0 5f
C7[20] S0[20] 0 5f
C7[19] S0[19] 0 5f
C7[18] S0[18] 0 5f
C7[17] S0[17] 0 5f
C7[16] S0[16] 0 5f
C7[15] S0[15] 0 5f
C7[14] S0[14] 0 5f
C7[13] S0[13] 0 5f
C7[12] S0[12] 0 5f
C7[11] S0[11] 0 5f
C7[10] S0[10] 0 5f
C7[9] S0[9] 0 5f
C7[8] S0[8] 0 5f
C7[7] S0[7] 0 5f
C7[6] S0[6] 0 5f
C7[5] S0[5] 0 5f
C7[4] S0[4] 0 5f
C7[3] S0[3] 0 5f
C7[2] S0[2] 0 5f
C7[1] S0[1] 0 5f
C7[0] S0[0] 0 5f
C8[255] CARRY0[255] 0 5f
C8[254] CARRY0[254] 0 5f
C8[253] CARRY0[253] 0 5f
C8[252] CARRY0[252] 0 5f
C8[251] CARRY0[251] 0 5f
C8[250] CARRY0[250] 0 5f
C8[249] CARRY0[249] 0 5f
C8[248] CARRY0[248] 0 5f
C8[247] CARRY0[247] 0 5f
C8[246] CARRY0[246] 0 5f
C8[245] CARRY0[245] 0 5f
C8[244] CARRY0[244] 0 5f
C8[243] CARRY0[243] 0 5f
C8[242] CARRY0[242] 0 5f
C8[241] CARRY0[241] 0 5f
C8[240] CARRY0[240] 0 5f
C8[239] CARRY0[239] 0 5f
C8[238] CARRY0[238] 0 5f
C8[237] CARRY0[237] 0 5f
C8[236] CARRY0[236] 0 5f
C8[235] CARRY0[235] 0 5f
C8[234] CARRY0[234] 0 5f
C8[233] CARRY0[233] 0 5f
C8[232] CARRY0[232] 0 5f
C8[231] CARRY0[231] 0 5f
C8[230] CARRY0[230] 0 5f
C8[229] CARRY0[229] 0 5f
C8[228] CARRY0[228] 0 5f
C8[227] CARRY0[227] 0 5f
C8[226] CARRY0[226] 0 5f
C8[225] CARRY0[225] 0 5f
C8[224] CARRY0[224] 0 5f
C8[223] CARRY0[223] 0 5f
C8[222] CARRY0[222] 0 5f
C8[221] CARRY0[221] 0 5f
C8[220] CARRY0[220] 0 5f
C8[219] CARRY0[219] 0 5f
C8[218] CARRY0[218] 0 5f
C8[217] CARRY0[217] 0 5f
C8[216] CARRY0[216] 0 5f
C8[215] CARRY0[215] 0 5f
C8[214] CARRY0[214] 0 5f
C8[213] CARRY0[213] 0 5f
C8[212] CARRY0[212] 0 5f
C8[211] CARRY0[211] 0 5f
C8[210] CARRY0[210] 0 5f
C8[209] CARRY0[209] 0 5f
C8[208] CARRY0[208] 0 5f
C8[207] CARRY0[207] 0 5f
C8[206] CARRY0[206] 0 5f
C8[205] CARRY0[205] 0 5f
C8[204] CARRY0[204] 0 5f
C8[203] CARRY0[203] 0 5f
C8[202] CARRY0[202] 0 5f
C8[201] CARRY0[201] 0 5f
C8[200] CARRY0[200] 0 5f
C8[199] CARRY0[199] 0 5f
C8[198] CARRY0[198] 0 5f
C8[197] CARRY0[197] 0 5f
C8[196] CARRY0[196] 0 5f
C8[195] CARRY0[195] 0 5f
C8[194] CARRY0[194] 0 5f
C8[193] CARRY0[193] 0 5f
C8[192] CARRY0[192] 0 5f
C8[191] CARRY0[191] 0 5f
C8[190] CARRY0[190] 0 5f
C8[189] CARRY0[189] 0 5f
C8[188] CARRY0[188] 0 5f
C8[187] CARRY0[187] 0 5f
C8[186] CARRY0[186] 0 5f
C8[185] CARRY0[185] 0 5f
C8[184] CARRY0[184] 0 5f
C8[183] CARRY0[183] 0 5f
C8[182] CARRY0[182] 0 5f
C8[181] CARRY0[181] 0 5f
C8[180] CARRY0[180] 0 5f
C8[179] CARRY0[179] 0 5f
C8[178] CARRY0[178] 0 5f
C8[177] CARRY0[177] 0 5f
C8[176] CARRY0[176] 0 5f
C8[175] CARRY0[175] 0 5f
C8[174] CARRY0[174] 0 5f
C8[173] CARRY0[173] 0 5f
C8[172] CARRY0[172] 0 5f
C8[171] CARRY0[171] 0 5f
C8[170] CARRY0[170] 0 5f
C8[169] CARRY0[169] 0 5f
C8[168] CARRY0[168] 0 5f
C8[167] CARRY0[167] 0 5f
C8[166] CARRY0[166] 0 5f
C8[165] CARRY0[165] 0 5f
C8[164] CARRY0[164] 0 5f
C8[163] CARRY0[163] 0 5f
C8[162] CARRY0[162] 0 5f
C8[161] CARRY0[161] 0 5f
C8[160] CARRY0[160] 0 5f
C8[159] CARRY0[159] 0 5f
C8[158] CARRY0[158] 0 5f
C8[157] CARRY0[157] 0 5f
C8[156] CARRY0[156] 0 5f
C8[155] CARRY0[155] 0 5f
C8[154] CARRY0[154] 0 5f
C8[153] CARRY0[153] 0 5f
C8[152] CARRY0[152] 0 5f
C8[151] CARRY0[151] 0 5f
C8[150] CARRY0[150] 0 5f
C8[149] CARRY0[149] 0 5f
C8[148] CARRY0[148] 0 5f
C8[147] CARRY0[147] 0 5f
C8[146] CARRY0[146] 0 5f
C8[145] CARRY0[145] 0 5f
C8[144] CARRY0[144] 0 5f
C8[143] CARRY0[143] 0 5f
C8[142] CARRY0[142] 0 5f
C8[141] CARRY0[141] 0 5f
C8[140] CARRY0[140] 0 5f
C8[139] CARRY0[139] 0 5f
C8[138] CARRY0[138] 0 5f
C8[137] CARRY0[137] 0 5f
C8[136] CARRY0[136] 0 5f
C8[135] CARRY0[135] 0 5f
C8[134] CARRY0[134] 0 5f
C8[133] CARRY0[133] 0 5f
C8[132] CARRY0[132] 0 5f
C8[131] CARRY0[131] 0 5f
C8[130] CARRY0[130] 0 5f
C8[129] CARRY0[129] 0 5f
C8[128] CARRY0[128] 0 5f
C8[127] CARRY0[127] 0 5f
C8[126] CARRY0[126] 0 5f
C8[125] CARRY0[125] 0 5f
C8[124] CARRY0[124] 0 5f
C8[123] CARRY0[123] 0 5f
C8[122] CARRY0[122] 0 5f
C8[121] CARRY0[121] 0 5f
C8[120] CARRY0[120] 0 5f
C8[119] CARRY0[119] 0 5f
C8[118] CARRY0[118] 0 5f
C8[117] CARRY0[117] 0 5f
C8[116] CARRY0[116] 0 5f
C8[115] CARRY0[115] 0 5f
C8[114] CARRY0[114] 0 5f
C8[113] CARRY0[113] 0 5f
C8[112] CARRY0[112] 0 5f
C8[111] CARRY0[111] 0 5f
C8[110] CARRY0[110] 0 5f
C8[109] CARRY0[109] 0 5f
C8[108] CARRY0[108] 0 5f
C8[107] CARRY0[107] 0 5f
C8[106] CARRY0[106] 0 5f
C8[105] CARRY0[105] 0 5f
C8[104] CARRY0[104] 0 5f
C8[103] CARRY0[103] 0 5f
C8[102] CARRY0[102] 0 5f
C8[101] CARRY0[101] 0 5f
C8[100] CARRY0[100] 0 5f
C8[99] CARRY0[99] 0 5f
C8[98] CARRY0[98] 0 5f
C8[97] CARRY0[97] 0 5f
C8[96] CARRY0[96] 0 5f
C8[95] CARRY0[95] 0 5f
C8[94] CARRY0[94] 0 5f
C8[93] CARRY0[93] 0 5f
C8[92] CARRY0[92] 0 5f
C8[91] CARRY0[91] 0 5f
C8[90] CARRY0[90] 0 5f
C8[89] CARRY0[89] 0 5f
C8[88] CARRY0[88] 0 5f
C8[87] CARRY0[87] 0 5f
C8[86] CARRY0[86] 0 5f
C8[85] CARRY0[85] 0 5f
C8[84] CARRY0[84] 0 5f
C8[83] CARRY0[83] 0 5f
C8[82] CARRY0[82] 0 5f
C8[81] CARRY0[81] 0 5f
C8[80] CARRY0[80] 0 5f
C8[79] CARRY0[79] 0 5f
C8[78] CARRY0[78] 0 5f
C8[77] CARRY0[77] 0 5f
C8[76] CARRY0[76] 0 5f
C8[75] CARRY0[75] 0 5f
C8[74] CARRY0[74] 0 5f
C8[73] CARRY0[73] 0 5f
C8[72] CARRY0[72] 0 5f
C8[71] CARRY0[71] 0 5f
C8[70] CARRY0[70] 0 5f
C8[69] CARRY0[69] 0 5f
C8[68] CARRY0[68] 0 5f
C8[67] CARRY0[67] 0 5f
C8[66] CARRY0[66] 0 5f
C8[65] CARRY0[65] 0 5f
C8[64] CARRY0[64] 0 5f
C8[63] CARRY0[63] 0 5f
C8[62] CARRY0[62] 0 5f
C8[61] CARRY0[61] 0 5f
C8[60] CARRY0[60] 0 5f
C8[59] CARRY0[59] 0 5f
C8[58] CARRY0[58] 0 5f
C8[57] CARRY0[57] 0 5f
C8[56] CARRY0[56] 0 5f
C8[55] CARRY0[55] 0 5f
C8[54] CARRY0[54] 0 5f
C8[53] CARRY0[53] 0 5f
C8[52] CARRY0[52] 0 5f
C8[51] CARRY0[51] 0 5f
C8[50] CARRY0[50] 0 5f
C8[49] CARRY0[49] 0 5f
C8[48] CARRY0[48] 0 5f
C8[47] CARRY0[47] 0 5f
C8[46] CARRY0[46] 0 5f
C8[45] CARRY0[45] 0 5f
C8[44] CARRY0[44] 0 5f
C8[43] CARRY0[43] 0 5f
C8[42] CARRY0[42] 0 5f
C8[41] CARRY0[41] 0 5f
C8[40] CARRY0[40] 0 5f
C8[39] CARRY0[39] 0 5f
C8[38] CARRY0[38] 0 5f
C8[37] CARRY0[37] 0 5f
C8[36] CARRY0[36] 0 5f
C8[35] CARRY0[35] 0 5f
C8[34] CARRY0[34] 0 5f
C8[33] CARRY0[33] 0 5f
C8[32] CARRY0[32] 0 5f
C8[31] CARRY0[31] 0 5f
C8[30] CARRY0[30] 0 5f
C8[29] CARRY0[29] 0 5f
C8[28] CARRY0[28] 0 5f
C8[27] CARRY0[27] 0 5f
C8[26] CARRY0[26] 0 5f
C8[25] CARRY0[25] 0 5f
C8[24] CARRY0[24] 0 5f
C8[23] CARRY0[23] 0 5f
C8[22] CARRY0[22] 0 5f
C8[21] CARRY0[21] 0 5f
C8[20] CARRY0[20] 0 5f
C8[19] CARRY0[19] 0 5f
C8[18] CARRY0[18] 0 5f
C8[17] CARRY0[17] 0 5f
C8[16] CARRY0[16] 0 5f
C8[15] CARRY0[15] 0 5f
C8[14] CARRY0[14] 0 5f
C8[13] CARRY0[13] 0 5f
C8[12] CARRY0[12] 0 5f
C8[11] CARRY0[11] 0 5f
C8[10] CARRY0[10] 0 5f
C8[9] CARRY0[9] 0 5f
C8[8] CARRY0[8] 0 5f
C8[7] CARRY0[7] 0 5f
C8[6] CARRY0[6] 0 5f
C8[5] CARRY0[5] 0 5f
C8[4] CARRY0[4] 0 5f
C8[3] CARRY0[3] 0 5f
C8[2] CARRY0[2] 0 5f
C8[1] CARRY0[1] 0 5f
C8[0] CARRY0[0] 0 5f
xadd32 A[31] A[30] A[29] A[28] A[27] A[26] A[25] A[24] A[23] A[22] A[21] A[20] A[19] A[18] A[17] A[16] A[15] A[14] A[13] A[12]
+ A[11] A[10] A[9] A[8] A[7] A[6] A[5] A[4] A[3] A[2] A[1] A[0] S2[31] S2[30] S2[29] S2[28] S2[27] S2[26] S2[25] S2[24] S2[23] S2[22]
+ S2[21] S2[20] S2[19] S2[18] S2[17] S2[16] S2[15] S2[14] S2[13] S2[12] S2[11] S2[10] S2[9] S2[8] S2[7] S2[6] S2[5] S2[4] S2[3] S2[2]
+ S2[1] S2[0] B[31] B[30] B[29] B[28] B[27] B[26] B[25] B[24] B[23] B[22] B[21] B[20] B[19] B[18] B[17] B[16] B[15] B[14] B[13] B[12]
+ B[11] B[10] B[9] B[8] B[7] B[6] B[5] B[4] B[3] B[2] B[1] B[0] COUT2 SG2 CIN SP2 adder_32bit
.save v(cout2)
xaddcarry32[31] A[31] B[31] CARRY1[30] VSS VSS VCC VCC CARRY1[31] S1[31] sky130_fd_sc_hd__fah_1
xaddcarry32[30] A[30] B[30] CARRY1[29] VSS VSS VCC VCC CARRY1[30] S1[30] sky130_fd_sc_hd__fah_1
xaddcarry32[29] A[29] B[29] CARRY1[28] VSS VSS VCC VCC CARRY1[29] S1[29] sky130_fd_sc_hd__fah_1
xaddcarry32[28] A[28] B[28] CARRY1[27] VSS VSS VCC VCC CARRY1[28] S1[28] sky130_fd_sc_hd__fah_1
xaddcarry32[27] A[27] B[27] CARRY1[26] VSS VSS VCC VCC CARRY1[27] S1[27] sky130_fd_sc_hd__fah_1
xaddcarry32[26] A[26] B[26] CARRY1[25] VSS VSS VCC VCC CARRY1[26] S1[26] sky130_fd_sc_hd__fah_1
xaddcarry32[25] A[25] B[25] CARRY1[24] VSS VSS VCC VCC CARRY1[25] S1[25] sky130_fd_sc_hd__fah_1
xaddcarry32[24] A[24] B[24] CARRY1[23] VSS VSS VCC VCC CARRY1[24] S1[24] sky130_fd_sc_hd__fah_1
xaddcarry32[23] A[23] B[23] CARRY1[22] VSS VSS VCC VCC CARRY1[23] S1[23] sky130_fd_sc_hd__fah_1
xaddcarry32[22] A[22] B[22] CARRY1[21] VSS VSS VCC VCC CARRY1[22] S1[22] sky130_fd_sc_hd__fah_1
xaddcarry32[21] A[21] B[21] CARRY1[20] VSS VSS VCC VCC CARRY1[21] S1[21] sky130_fd_sc_hd__fah_1
xaddcarry32[20] A[20] B[20] CARRY1[19] VSS VSS VCC VCC CARRY1[20] S1[20] sky130_fd_sc_hd__fah_1
xaddcarry32[19] A[19] B[19] CARRY1[18] VSS VSS VCC VCC CARRY1[19] S1[19] sky130_fd_sc_hd__fah_1
xaddcarry32[18] A[18] B[18] CARRY1[17] VSS VSS VCC VCC CARRY1[18] S1[18] sky130_fd_sc_hd__fah_1
xaddcarry32[17] A[17] B[17] CARRY1[16] VSS VSS VCC VCC CARRY1[17] S1[17] sky130_fd_sc_hd__fah_1
xaddcarry32[16] A[16] B[16] CARRY1[15] VSS VSS VCC VCC CARRY1[16] S1[16] sky130_fd_sc_hd__fah_1
xaddcarry32[15] A[15] B[15] CARRY1[14] VSS VSS VCC VCC CARRY1[15] S1[15] sky130_fd_sc_hd__fah_1
xaddcarry32[14] A[14] B[14] CARRY1[13] VSS VSS VCC VCC CARRY1[14] S1[14] sky130_fd_sc_hd__fah_1
xaddcarry32[13] A[13] B[13] CARRY1[12] VSS VSS VCC VCC CARRY1[13] S1[13] sky130_fd_sc_hd__fah_1
xaddcarry32[12] A[12] B[12] CARRY1[11] VSS VSS VCC VCC CARRY1[12] S1[12] sky130_fd_sc_hd__fah_1
xaddcarry32[11] A[11] B[11] CARRY1[10] VSS VSS VCC VCC CARRY1[11] S1[11] sky130_fd_sc_hd__fah_1
xaddcarry32[10] A[10] B[10] CARRY1[9] VSS VSS VCC VCC CARRY1[10] S1[10] sky130_fd_sc_hd__fah_1
xaddcarry32[9] A[9] B[9] CARRY1[8] VSS VSS VCC VCC CARRY1[9] S1[9] sky130_fd_sc_hd__fah_1
xaddcarry32[8] A[8] B[8] CARRY1[7] VSS VSS VCC VCC CARRY1[8] S1[8] sky130_fd_sc_hd__fah_1
xaddcarry32[7] A[7] B[7] CARRY1[6] VSS VSS VCC VCC CARRY1[7] S1[7] sky130_fd_sc_hd__fah_1
xaddcarry32[6] A[6] B[6] CARRY1[5] VSS VSS VCC VCC CARRY1[6] S1[6] sky130_fd_sc_hd__fah_1
xaddcarry32[5] A[5] B[5] CARRY1[4] VSS VSS VCC VCC CARRY1[5] S1[5] sky130_fd_sc_hd__fah_1
xaddcarry32[4] A[4] B[4] CARRY1[3] VSS VSS VCC VCC CARRY1[4] S1[4] sky130_fd_sc_hd__fah_1
xaddcarry32[3] A[3] B[3] CARRY1[2] VSS VSS VCC VCC CARRY1[3] S1[3] sky130_fd_sc_hd__fah_1
xaddcarry32[2] A[2] B[2] CARRY1[1] VSS VSS VCC VCC CARRY1[2] S1[2] sky130_fd_sc_hd__fah_1
xaddcarry32[1] A[1] B[1] CARRY1[0] VSS VSS VCC VCC CARRY1[1] S1[1] sky130_fd_sc_hd__fah_1
xaddcarry32[0] A[0] B[0] CIN VSS VSS VCC VCC CARRY1[0] S1[0] sky130_fd_sc_hd__fah_1
.save v(carry1[31])
.save v(carry1[30])
.save v(carry1[29])
.save v(carry1[28])
.save v(carry1[27])
.save v(carry1[26])
.save v(carry1[25])
.save v(carry1[24])
.save v(carry1[23])
.save v(carry1[22])
.save v(carry1[21])
.save v(carry1[20])
.save v(carry1[19])
.save v(carry1[18])
.save v(carry1[17])
.save v(carry1[16])
.save v(carry1[15])
.save v(carry1[14])
.save v(carry1[13])
.save v(carry1[12])
.save v(carry1[11])
.save v(carry1[10])
.save v(carry1[9])
.save v(carry1[8])
.save v(carry1[7])
.save v(carry1[6])
.save v(carry1[5])
.save v(carry1[4])
.save v(carry1[3])
.save v(carry1[2])
.save v(carry1[1])
.save v(carry1[0])
.save v(s1[31])
.save v(s1[30])
.save v(s1[29])
.save v(s1[28])
.save v(s1[27])
.save v(s1[26])
.save v(s1[25])
.save v(s1[24])
.save v(s1[23])
.save v(s1[22])
.save v(s1[21])
.save v(s1[20])
.save v(s1[19])
.save v(s1[18])
.save v(s1[17])
.save v(s1[16])
.save v(s1[15])
.save v(s1[14])
.save v(s1[13])
.save v(s1[12])
.save v(s1[11])
.save v(s1[10])
.save v(s1[9])
.save v(s1[8])
.save v(s1[7])
.save v(s1[6])
.save v(s1[5])
.save v(s1[4])
.save v(s1[3])
.save v(s1[2])
.save v(s1[1])
.save v(s1[0])
.save v(s2[31])
.save v(s2[30])
.save v(s2[29])
.save v(s2[28])
.save v(s2[27])
.save v(s2[26])
.save v(s2[25])
.save v(s2[24])
.save v(s2[23])
.save v(s2[22])
.save v(s2[21])
.save v(s2[20])
.save v(s2[19])
.save v(s2[18])
.save v(s2[17])
.save v(s2[16])
.save v(s2[15])
.save v(s2[14])
.save v(s2[13])
.save v(s2[12])
.save v(s2[11])
.save v(s2[10])
.save v(s2[9])
.save v(s2[8])
.save v(s2[7])
.save v(s2[6])
.save v(s2[5])
.save v(s2[4])
.save v(s2[3])
.save v(s2[2])
.save v(s2[1])
.save v(s2[0])
C2[255] S3[255] 0 5f
C2[254] S3[254] 0 5f
C2[253] S3[253] 0 5f
C2[252] S3[252] 0 5f
C2[251] S3[251] 0 5f
C2[250] S3[250] 0 5f
C2[249] S3[249] 0 5f
C2[248] S3[248] 0 5f
C2[247] S3[247] 0 5f
C2[246] S3[246] 0 5f
C2[245] S3[245] 0 5f
C2[244] S3[244] 0 5f
C2[243] S3[243] 0 5f
C2[242] S3[242] 0 5f
C2[241] S3[241] 0 5f
C2[240] S3[240] 0 5f
C2[239] S3[239] 0 5f
C2[238] S3[238] 0 5f
C2[237] S3[237] 0 5f
C2[236] S3[236] 0 5f
C2[235] S3[235] 0 5f
C2[234] S3[234] 0 5f
C2[233] S3[233] 0 5f
C2[232] S3[232] 0 5f
C2[231] S3[231] 0 5f
C2[230] S3[230] 0 5f
C2[229] S3[229] 0 5f
C2[228] S3[228] 0 5f
C2[227] S3[227] 0 5f
C2[226] S3[226] 0 5f
C2[225] S3[225] 0 5f
C2[224] S3[224] 0 5f
C2[223] S3[223] 0 5f
C2[222] S3[222] 0 5f
C2[221] S3[221] 0 5f
C2[220] S3[220] 0 5f
C2[219] S3[219] 0 5f
C2[218] S3[218] 0 5f
C2[217] S3[217] 0 5f
C2[216] S3[216] 0 5f
C2[215] S3[215] 0 5f
C2[214] S3[214] 0 5f
C2[213] S3[213] 0 5f
C2[212] S3[212] 0 5f
C2[211] S3[211] 0 5f
C2[210] S3[210] 0 5f
C2[209] S3[209] 0 5f
C2[208] S3[208] 0 5f
C2[207] S3[207] 0 5f
C2[206] S3[206] 0 5f
C2[205] S3[205] 0 5f
C2[204] S3[204] 0 5f
C2[203] S3[203] 0 5f
C2[202] S3[202] 0 5f
C2[201] S3[201] 0 5f
C2[200] S3[200] 0 5f
C2[199] S3[199] 0 5f
C2[198] S3[198] 0 5f
C2[197] S3[197] 0 5f
C2[196] S3[196] 0 5f
C2[195] S3[195] 0 5f
C2[194] S3[194] 0 5f
C2[193] S3[193] 0 5f
C2[192] S3[192] 0 5f
C2[191] S3[191] 0 5f
C2[190] S3[190] 0 5f
C2[189] S3[189] 0 5f
C2[188] S3[188] 0 5f
C2[187] S3[187] 0 5f
C2[186] S3[186] 0 5f
C2[185] S3[185] 0 5f
C2[184] S3[184] 0 5f
C2[183] S3[183] 0 5f
C2[182] S3[182] 0 5f
C2[181] S3[181] 0 5f
C2[180] S3[180] 0 5f
C2[179] S3[179] 0 5f
C2[178] S3[178] 0 5f
C2[177] S3[177] 0 5f
C2[176] S3[176] 0 5f
C2[175] S3[175] 0 5f
C2[174] S3[174] 0 5f
C2[173] S3[173] 0 5f
C2[172] S3[172] 0 5f
C2[171] S3[171] 0 5f
C2[170] S3[170] 0 5f
C2[169] S3[169] 0 5f
C2[168] S3[168] 0 5f
C2[167] S3[167] 0 5f
C2[166] S3[166] 0 5f
C2[165] S3[165] 0 5f
C2[164] S3[164] 0 5f
C2[163] S3[163] 0 5f
C2[162] S3[162] 0 5f
C2[161] S3[161] 0 5f
C2[160] S3[160] 0 5f
C2[159] S3[159] 0 5f
C2[158] S3[158] 0 5f
C2[157] S3[157] 0 5f
C2[156] S3[156] 0 5f
C2[155] S3[155] 0 5f
C2[154] S3[154] 0 5f
C2[153] S3[153] 0 5f
C2[152] S3[152] 0 5f
C2[151] S3[151] 0 5f
C2[150] S3[150] 0 5f
C2[149] S3[149] 0 5f
C2[148] S3[148] 0 5f
C2[147] S3[147] 0 5f
C2[146] S3[146] 0 5f
C2[145] S3[145] 0 5f
C2[144] S3[144] 0 5f
C2[143] S3[143] 0 5f
C2[142] S3[142] 0 5f
C2[141] S3[141] 0 5f
C2[140] S3[140] 0 5f
C2[139] S3[139] 0 5f
C2[138] S3[138] 0 5f
C2[137] S3[137] 0 5f
C2[136] S3[136] 0 5f
C2[135] S3[135] 0 5f
C2[134] S3[134] 0 5f
C2[133] S3[133] 0 5f
C2[132] S3[132] 0 5f
C2[131] S3[131] 0 5f
C2[130] S3[130] 0 5f
C2[129] S3[129] 0 5f
C2[128] S3[128] 0 5f
C2[127] S3[127] 0 5f
C2[126] S3[126] 0 5f
C2[125] S3[125] 0 5f
C2[124] S3[124] 0 5f
C2[123] S3[123] 0 5f
C2[122] S3[122] 0 5f
C2[121] S3[121] 0 5f
C2[120] S3[120] 0 5f
C2[119] S3[119] 0 5f
C2[118] S3[118] 0 5f
C2[117] S3[117] 0 5f
C2[116] S3[116] 0 5f
C2[115] S3[115] 0 5f
C2[114] S3[114] 0 5f
C2[113] S3[113] 0 5f
C2[112] S3[112] 0 5f
C2[111] S3[111] 0 5f
C2[110] S3[110] 0 5f
C2[109] S3[109] 0 5f
C2[108] S3[108] 0 5f
C2[107] S3[107] 0 5f
C2[106] S3[106] 0 5f
C2[105] S3[105] 0 5f
C2[104] S3[104] 0 5f
C2[103] S3[103] 0 5f
C2[102] S3[102] 0 5f
C2[101] S3[101] 0 5f
C2[100] S3[100] 0 5f
C2[99] S3[99] 0 5f
C2[98] S3[98] 0 5f
C2[97] S3[97] 0 5f
C2[96] S3[96] 0 5f
C2[95] S3[95] 0 5f
C2[94] S3[94] 0 5f
C2[93] S3[93] 0 5f
C2[92] S3[92] 0 5f
C2[91] S3[91] 0 5f
C2[90] S3[90] 0 5f
C2[89] S3[89] 0 5f
C2[88] S3[88] 0 5f
C2[87] S3[87] 0 5f
C2[86] S3[86] 0 5f
C2[85] S3[85] 0 5f
C2[84] S3[84] 0 5f
C2[83] S3[83] 0 5f
C2[82] S3[82] 0 5f
C2[81] S3[81] 0 5f
C2[80] S3[80] 0 5f
C2[79] S3[79] 0 5f
C2[78] S3[78] 0 5f
C2[77] S3[77] 0 5f
C2[76] S3[76] 0 5f
C2[75] S3[75] 0 5f
C2[74] S3[74] 0 5f
C2[73] S3[73] 0 5f
C2[72] S3[72] 0 5f
C2[71] S3[71] 0 5f
C2[70] S3[70] 0 5f
C2[69] S3[69] 0 5f
C2[68] S3[68] 0 5f
C2[67] S3[67] 0 5f
C2[66] S3[66] 0 5f
C2[65] S3[65] 0 5f
C2[64] S3[64] 0 5f
C2[63] S3[63] 0 5f
C2[62] S3[62] 0 5f
C2[61] S3[61] 0 5f
C2[60] S3[60] 0 5f
C2[59] S3[59] 0 5f
C2[58] S3[58] 0 5f
C2[57] S3[57] 0 5f
C2[56] S3[56] 0 5f
C2[55] S3[55] 0 5f
C2[54] S3[54] 0 5f
C2[53] S3[53] 0 5f
C2[52] S3[52] 0 5f
C2[51] S3[51] 0 5f
C2[50] S3[50] 0 5f
C2[49] S3[49] 0 5f
C2[48] S3[48] 0 5f
C2[47] S3[47] 0 5f
C2[46] S3[46] 0 5f
C2[45] S3[45] 0 5f
C2[44] S3[44] 0 5f
C2[43] S3[43] 0 5f
C2[42] S3[42] 0 5f
C2[41] S3[41] 0 5f
C2[40] S3[40] 0 5f
C2[39] S3[39] 0 5f
C2[38] S3[38] 0 5f
C2[37] S3[37] 0 5f
C2[36] S3[36] 0 5f
C2[35] S3[35] 0 5f
C2[34] S3[34] 0 5f
C2[33] S3[33] 0 5f
C2[32] S3[32] 0 5f
C2[31] S3[31] 0 5f
C2[30] S3[30] 0 5f
C2[29] S3[29] 0 5f
C2[28] S3[28] 0 5f
C2[27] S3[27] 0 5f
C2[26] S3[26] 0 5f
C2[25] S3[25] 0 5f
C2[24] S3[24] 0 5f
C2[23] S3[23] 0 5f
C2[22] S3[22] 0 5f
C2[21] S3[21] 0 5f
C2[20] S3[20] 0 5f
C2[19] S3[19] 0 5f
C2[18] S3[18] 0 5f
C2[17] S3[17] 0 5f
C2[16] S3[16] 0 5f
C2[15] S3[15] 0 5f
C2[14] S3[14] 0 5f
C2[13] S3[13] 0 5f
C2[12] S3[12] 0 5f
C2[11] S3[11] 0 5f
C2[10] S3[10] 0 5f
C2[9] S3[9] 0 5f
C2[8] S3[8] 0 5f
C2[7] S3[7] 0 5f
C2[6] S3[6] 0 5f
C2[5] S3[5] 0 5f
C2[4] S3[4] 0 5f
C2[3] S3[3] 0 5f
C2[2] S3[2] 0 5f
C2[1] S3[1] 0 5f
C2[0] S3[0] 0 5f
C3[255] S2[31] 0 5f
C3[254] S2[30] 0 5f
C3[253] S2[29] 0 5f
C3[252] S2[28] 0 5f
C3[251] S2[27] 0 5f
C3[250] S2[26] 0 5f
C3[249] S2[25] 0 5f
C3[248] S2[24] 0 5f
C3[247] S2[23] 0 5f
C3[246] S2[22] 0 5f
C3[245] S2[21] 0 5f
C3[244] S2[20] 0 5f
C3[243] S2[19] 0 5f
C3[242] S2[18] 0 5f
C3[241] S2[17] 0 5f
C3[240] S2[16] 0 5f
C3[239] S2[15] 0 5f
C3[238] S2[14] 0 5f
C3[237] S2[13] 0 5f
C3[236] S2[12] 0 5f
C3[235] S2[11] 0 5f
C3[234] S2[10] 0 5f
C3[233] S2[9] 0 5f
C3[232] S2[8] 0 5f
C3[231] S2[7] 0 5f
C3[230] S2[6] 0 5f
C3[229] S2[5] 0 5f
C3[228] S2[4] 0 5f
C3[227] S2[3] 0 5f
C3[226] S2[2] 0 5f
C3[225] S2[1] 0 5f
C3[224] S2[0] 0 5f
C3[223] S2[31] 0 5f
C3[222] S2[30] 0 5f
C3[221] S2[29] 0 5f
C3[220] S2[28] 0 5f
C3[219] S2[27] 0 5f
C3[218] S2[26] 0 5f
C3[217] S2[25] 0 5f
C3[216] S2[24] 0 5f
C3[215] S2[23] 0 5f
C3[214] S2[22] 0 5f
C3[213] S2[21] 0 5f
C3[212] S2[20] 0 5f
C3[211] S2[19] 0 5f
C3[210] S2[18] 0 5f
C3[209] S2[17] 0 5f
C3[208] S2[16] 0 5f
C3[207] S2[15] 0 5f
C3[206] S2[14] 0 5f
C3[205] S2[13] 0 5f
C3[204] S2[12] 0 5f
C3[203] S2[11] 0 5f
C3[202] S2[10] 0 5f
C3[201] S2[9] 0 5f
C3[200] S2[8] 0 5f
C3[199] S2[7] 0 5f
C3[198] S2[6] 0 5f
C3[197] S2[5] 0 5f
C3[196] S2[4] 0 5f
C3[195] S2[3] 0 5f
C3[194] S2[2] 0 5f
C3[193] S2[1] 0 5f
C3[192] S2[0] 0 5f
C3[191] S2[31] 0 5f
C3[190] S2[30] 0 5f
C3[189] S2[29] 0 5f
C3[188] S2[28] 0 5f
C3[187] S2[27] 0 5f
C3[186] S2[26] 0 5f
C3[185] S2[25] 0 5f
C3[184] S2[24] 0 5f
C3[183] S2[23] 0 5f
C3[182] S2[22] 0 5f
C3[181] S2[21] 0 5f
C3[180] S2[20] 0 5f
C3[179] S2[19] 0 5f
C3[178] S2[18] 0 5f
C3[177] S2[17] 0 5f
C3[176] S2[16] 0 5f
C3[175] S2[15] 0 5f
C3[174] S2[14] 0 5f
C3[173] S2[13] 0 5f
C3[172] S2[12] 0 5f
C3[171] S2[11] 0 5f
C3[170] S2[10] 0 5f
C3[169] S2[9] 0 5f
C3[168] S2[8] 0 5f
C3[167] S2[7] 0 5f
C3[166] S2[6] 0 5f
C3[165] S2[5] 0 5f
C3[164] S2[4] 0 5f
C3[163] S2[3] 0 5f
C3[162] S2[2] 0 5f
C3[161] S2[1] 0 5f
C3[160] S2[0] 0 5f
C3[159] S2[31] 0 5f
C3[158] S2[30] 0 5f
C3[157] S2[29] 0 5f
C3[156] S2[28] 0 5f
C3[155] S2[27] 0 5f
C3[154] S2[26] 0 5f
C3[153] S2[25] 0 5f
C3[152] S2[24] 0 5f
C3[151] S2[23] 0 5f
C3[150] S2[22] 0 5f
C3[149] S2[21] 0 5f
C3[148] S2[20] 0 5f
C3[147] S2[19] 0 5f
C3[146] S2[18] 0 5f
C3[145] S2[17] 0 5f
C3[144] S2[16] 0 5f
C3[143] S2[15] 0 5f
C3[142] S2[14] 0 5f
C3[141] S2[13] 0 5f
C3[140] S2[12] 0 5f
C3[139] S2[11] 0 5f
C3[138] S2[10] 0 5f
C3[137] S2[9] 0 5f
C3[136] S2[8] 0 5f
C3[135] S2[7] 0 5f
C3[134] S2[6] 0 5f
C3[133] S2[5] 0 5f
C3[132] S2[4] 0 5f
C3[131] S2[3] 0 5f
C3[130] S2[2] 0 5f
C3[129] S2[1] 0 5f
C3[128] S2[0] 0 5f
C3[127] S2[31] 0 5f
C3[126] S2[30] 0 5f
C3[125] S2[29] 0 5f
C3[124] S2[28] 0 5f
C3[123] S2[27] 0 5f
C3[122] S2[26] 0 5f
C3[121] S2[25] 0 5f
C3[120] S2[24] 0 5f
C3[119] S2[23] 0 5f
C3[118] S2[22] 0 5f
C3[117] S2[21] 0 5f
C3[116] S2[20] 0 5f
C3[115] S2[19] 0 5f
C3[114] S2[18] 0 5f
C3[113] S2[17] 0 5f
C3[112] S2[16] 0 5f
C3[111] S2[15] 0 5f
C3[110] S2[14] 0 5f
C3[109] S2[13] 0 5f
C3[108] S2[12] 0 5f
C3[107] S2[11] 0 5f
C3[106] S2[10] 0 5f
C3[105] S2[9] 0 5f
C3[104] S2[8] 0 5f
C3[103] S2[7] 0 5f
C3[102] S2[6] 0 5f
C3[101] S2[5] 0 5f
C3[100] S2[4] 0 5f
C3[99] S2[3] 0 5f
C3[98] S2[2] 0 5f
C3[97] S2[1] 0 5f
C3[96] S2[0] 0 5f
C3[95] S2[31] 0 5f
C3[94] S2[30] 0 5f
C3[93] S2[29] 0 5f
C3[92] S2[28] 0 5f
C3[91] S2[27] 0 5f
C3[90] S2[26] 0 5f
C3[89] S2[25] 0 5f
C3[88] S2[24] 0 5f
C3[87] S2[23] 0 5f
C3[86] S2[22] 0 5f
C3[85] S2[21] 0 5f
C3[84] S2[20] 0 5f
C3[83] S2[19] 0 5f
C3[82] S2[18] 0 5f
C3[81] S2[17] 0 5f
C3[80] S2[16] 0 5f
C3[79] S2[15] 0 5f
C3[78] S2[14] 0 5f
C3[77] S2[13] 0 5f
C3[76] S2[12] 0 5f
C3[75] S2[11] 0 5f
C3[74] S2[10] 0 5f
C3[73] S2[9] 0 5f
C3[72] S2[8] 0 5f
C3[71] S2[7] 0 5f
C3[70] S2[6] 0 5f
C3[69] S2[5] 0 5f
C3[68] S2[4] 0 5f
C3[67] S2[3] 0 5f
C3[66] S2[2] 0 5f
C3[65] S2[1] 0 5f
C3[64] S2[0] 0 5f
C3[63] S2[31] 0 5f
C3[62] S2[30] 0 5f
C3[61] S2[29] 0 5f
C3[60] S2[28] 0 5f
C3[59] S2[27] 0 5f
C3[58] S2[26] 0 5f
C3[57] S2[25] 0 5f
C3[56] S2[24] 0 5f
C3[55] S2[23] 0 5f
C3[54] S2[22] 0 5f
C3[53] S2[21] 0 5f
C3[52] S2[20] 0 5f
C3[51] S2[19] 0 5f
C3[50] S2[18] 0 5f
C3[49] S2[17] 0 5f
C3[48] S2[16] 0 5f
C3[47] S2[15] 0 5f
C3[46] S2[14] 0 5f
C3[45] S2[13] 0 5f
C3[44] S2[12] 0 5f
C3[43] S2[11] 0 5f
C3[42] S2[10] 0 5f
C3[41] S2[9] 0 5f
C3[40] S2[8] 0 5f
C3[39] S2[7] 0 5f
C3[38] S2[6] 0 5f
C3[37] S2[5] 0 5f
C3[36] S2[4] 0 5f
C3[35] S2[3] 0 5f
C3[34] S2[2] 0 5f
C3[33] S2[1] 0 5f
C3[32] S2[0] 0 5f
C3[31] S2[31] 0 5f
C3[30] S2[30] 0 5f
C3[29] S2[29] 0 5f
C3[28] S2[28] 0 5f
C3[27] S2[27] 0 5f
C3[26] S2[26] 0 5f
C3[25] S2[25] 0 5f
C3[24] S2[24] 0 5f
C3[23] S2[23] 0 5f
C3[22] S2[22] 0 5f
C3[21] S2[21] 0 5f
C3[20] S2[20] 0 5f
C3[19] S2[19] 0 5f
C3[18] S2[18] 0 5f
C3[17] S2[17] 0 5f
C3[16] S2[16] 0 5f
C3[15] S2[15] 0 5f
C3[14] S2[14] 0 5f
C3[13] S2[13] 0 5f
C3[12] S2[12] 0 5f
C3[11] S2[11] 0 5f
C3[10] S2[10] 0 5f
C3[9] S2[9] 0 5f
C3[8] S2[8] 0 5f
C3[7] S2[7] 0 5f
C3[6] S2[6] 0 5f
C3[5] S2[5] 0 5f
C3[4] S2[4] 0 5f
C3[3] S2[3] 0 5f
C3[2] S2[2] 0 5f
C3[1] S2[1] 0 5f
C3[0] S2[0] 0 5f
C6 COUT3 0 5f
C1 COUT2 0 5f
**** begin user architecture code

**** end user architecture code
**** begin user architecture code

*.option method=gear
.param VCC=1.8
* generate following file with Simulation->Utile stimuli editor and pressing 'Translate'
.include stimuli_test_carry_lookahead.cir
.control
* save all
tran 0.4n 250n uic
write test_carry_lookahead_ngspice.raw
acct
quit 0
.endc

**** end user architecture code
C4[31] S1[31] 0 5f
C4[30] S1[30] 0 5f
C4[29] S1[29] 0 5f
C4[28] S1[28] 0 5f
C4[27] S1[27] 0 5f
C4[26] S1[26] 0 5f
C4[25] S1[25] 0 5f
C4[24] S1[24] 0 5f
C4[23] S1[23] 0 5f
C4[22] S1[22] 0 5f
C4[21] S1[21] 0 5f
C4[20] S1[20] 0 5f
C4[19] S1[19] 0 5f
C4[18] S1[18] 0 5f
C4[17] S1[17] 0 5f
C4[16] S1[16] 0 5f
C4[15] S1[15] 0 5f
C4[14] S1[14] 0 5f
C4[13] S1[13] 0 5f
C4[12] S1[12] 0 5f
C4[11] S1[11] 0 5f
C4[10] S1[10] 0 5f
C4[9] S1[9] 0 5f
C4[8] S1[8] 0 5f
C4[7] S1[7] 0 5f
C4[6] S1[6] 0 5f
C4[5] S1[5] 0 5f
C4[4] S1[4] 0 5f
C4[3] S1[3] 0 5f
C4[2] S1[2] 0 5f
C4[1] S1[1] 0 5f
C4[0] S1[0] 0 5f
C5[31] CARRY1[31] 0 5f
C5[30] CARRY1[30] 0 5f
C5[29] CARRY1[29] 0 5f
C5[28] CARRY1[28] 0 5f
C5[27] CARRY1[27] 0 5f
C5[26] CARRY1[26] 0 5f
C5[25] CARRY1[25] 0 5f
C5[24] CARRY1[24] 0 5f
C5[23] CARRY1[23] 0 5f
C5[22] CARRY1[22] 0 5f
C5[21] CARRY1[21] 0 5f
C5[20] CARRY1[20] 0 5f
C5[19] CARRY1[19] 0 5f
C5[18] CARRY1[18] 0 5f
C5[17] CARRY1[17] 0 5f
C5[16] CARRY1[16] 0 5f
C5[15] CARRY1[15] 0 5f
C5[14] CARRY1[14] 0 5f
C5[13] CARRY1[13] 0 5f
C5[12] CARRY1[12] 0 5f
C5[11] CARRY1[11] 0 5f
C5[10] CARRY1[10] 0 5f
C5[9] CARRY1[9] 0 5f
C5[8] CARRY1[8] 0 5f
C5[7] CARRY1[7] 0 5f
C5[6] CARRY1[6] 0 5f
C5[5] CARRY1[5] 0 5f
C5[4] CARRY1[4] 0 5f
C5[3] CARRY1[3] 0 5f
C5[2] CARRY1[2] 0 5f
C5[1] CARRY1[1] 0 5f
C5[0] CARRY1[0] 0 5f
**** begin user architecture code

**** end user architecture code
.ends

* expanding   symbol:  sky130_tests/test_nand2_noschematic.sym # of pins=0
** sym_path: /pdk/sky130A/libs.tech/xschem/sky130_tests/test_nand2_noschematic.sym
** sch_path: /pdk/sky130A/libs.tech/xschem/sky130_tests/test_nand2_noschematic.sch
.subckt test_nand2_noschematic
*.opin ZZ[3],ZZ[2],ZZ[1],ZZ[0]
*.ipin AA[3],AA[2],AA[1],AA[0]
*.ipin BB
xax1[3] ZZ[3] AA[3] VCC VCC PCH w=2 l=0.1 nf=1
xax1[2] ZZ[2] AA[2] VCC VCC PCH w=2 l=0.1 nf=1
xax1[1] ZZ[1] AA[1] VCC VCC PCH w=2 l=0.1 nf=1
xax1[0] ZZ[0] AA[0] VCC VCC PCH w=2 l=0.1 nf=1
xbx1[3] ZZ[3] BB VCC VCC PCH w=2 l=0.1 nf=1
xbx1[2] ZZ[2] BB VCC VCC PCH w=2 l=0.1 nf=1
xbx1[1] ZZ[1] BB VCC VCC PCH w=2 l=0.1 nf=1
xbx1[0] ZZ[0] BB VCC VCC PCH w=2 l=0.1 nf=1
xcx1[3] ZZ[3] AA[3] nax1[3] VSS NCH w=4 l=0.1 nf=1
xcx1[2] ZZ[2] AA[2] nax1[2] VSS NCH w=4 l=0.1 nf=1
xcx1[1] ZZ[1] AA[1] nax1[1] VSS NCH w=4 l=0.1 nf=1
xcx1[0] ZZ[0] AA[0] nax1[0] VSS NCH w=4 l=0.1 nf=1
xdx1[3] nax1[3] BB VSS VSS NCH w=4 l=0.1 nf=1
xdx1[2] nax1[2] BB VSS VSS NCH w=4 l=0.1 nf=1
xdx1[1] nax1[1] BB VSS VSS NCH w=4 l=0.1 nf=1
xdx1[0] nax1[0] BB VSS VSS NCH w=4 l=0.1 nf=1
.ends

* expanding   symbol:  sky130_tests/test_s_xfer.sym # of pins=0
** sym_path: /pdk/sky130A/libs.tech/xschem/sky130_tests/test_s_xfer.sym
** sch_path: /pdk/sky130A/libs.tech/xschem/sky130_tests/test_s_xfer.sch
.subckt test_s_xfer
A1 A B integrator
**** begin user architecture code

.option savecurrents
.control
  save all
  tran 10n 10u
  write test_s_xfer.raw
.endc

**** end user architecture code
VIN A GND pwl 0 0 1u 0 1.001u 1
.ends

* expanding   symbol:  sky130_tests/test_multisim.sym # of pins=0
** sym_path: /pdk/sky130A/libs.tech/xschem/sky130_tests/test_multisim.sym
** sch_path: /pdk/sky130A/libs.tech/xschem/sky130_tests/test_multisim.sch
.subckt test_multisim
V4 VCC 0 pwl 0 0 1u 0 1.001u 1.8
R1 0 A 100K
C2 A VCC 30p
**** begin user architecture code

** ngspice
.control
  save all
  tran 1n 20u uic
  write test_multisim_ngspice.raw
  acct
  quit 0
.endc

**** end user architecture code
**** begin user architecture code

**** end user architecture code
.ends

* expanding   symbol:  sky130_tests/test_ac.sym # of pins=0
** sym_path: /pdk/sky130A/libs.tech/xschem/sky130_tests/test_ac.sym
** sch_path: /pdk/sky130A/libs.tech/xschem/sky130_tests/test_ac.sch
.subckt test_ac
XM1 G PLUS S GND sky130_fd_pr__nfet_01v8_lvt L=2 W=4 nf=1 ad=1.16 as=1.16 pd=8.58 ps=8.58 nrd=0.0725 nrs=0.0725 sa=0 sb=0 sd=0
+ mult=1
XM2 OUT MINUS S GND sky130_fd_pr__nfet_01v8_lvt L=2 W=4 nf=1 ad=1.16 as=1.16 pd=8.58 ps=8.58 nrd=0.0725 nrs=0.0725 sa=0 sb=0 sd=0
+ mult=1
XM4 net3 BIAS GND GND sky130_fd_pr__nfet_01v8_lvt L=4 W=4 nf=1 ad=1.16 as=1.16 pd=8.58 ps=8.58 nrd=0.0725 nrs=0.0725 sa=0 sb=0
+ sd=0 mult=1
XM3 OUT G VCC VCC sky130_fd_pr__pfet_01v8_lvt L=4 W=4 nf=1 ad=1.16 as=1.16 pd=8.58 ps=8.58 nrd=0.0725 nrs=0.0725 sa=0 sb=0 sd=0
+ mult=1
XM5 G G VCC VCC sky130_fd_pr__pfet_01v8_lvt L=4 W=4 nf=1 ad=1.16 as=1.16 pd=8.58 ps=8.58 nrd=0.0725 nrs=0.0725 sa=0 sb=0 sd=0
+ mult=1
Vtail S net3 0
.save i(vtail)
V1 BIAS GND 0.7
V2 VCC GND 1.8
V3 PLUS GND 0.91
V4 IN GND 0 ac 1 0 sin(0 1m 100meg 0 0 0)
**** begin user architecture code

.include test_ac.save
.option reltol=1e-5
+  abstol=1e-14 savecurrents
.control
  save all
  op
  remzerovec
  write test_ac.raw
  set appendwrite
  ac dec 10 1 1e12
  remzerovec
  write test_ac.raw
  tran 0.1n 100n
  write test_ac.raw
.endc

**** end user architecture code
**** begin user architecture code

**** end user architecture code
C2 MINUS IN 1T
L1 OUT MINUS 1T
E1 net1 GND S GND 1
XM6 net2 OUT net1 GND sky130_fd_pr__nfet_01v8_lvt L=2 W=4 nf=1 ad=1.16 as=1.16 pd=8.58 ps=8.58 nrd=0.0725 nrs=0.0725 sa=0 sb=0
+ sd=0 mult=1
E2 net2 GND OUT GND 1
.ends

* expanding   symbol:  sky130_tests/test_mos_binning.sym # of pins=0
** sym_path: /pdk/sky130A/libs.tech/xschem/sky130_tests/test_mos_binning.sym
** sch_path: /pdk/sky130A/libs.tech/xschem/sky130_tests/test_mos_binning.sch
.subckt test_mos_binning
Vd2 D net1 0
.save i(vd2)
XM2 net1 G S B sky130_fd_pr__nfet_01v8 L=LENGTH W=WIDTH nf=1 ad='int((1 + 1)/2) * WIDTH / 1 * 0.29' as='int((1 + 2)/2) * WIDTH / 1 * 0.29'
+ pd='2*int((1 + 1)/2) * (WIDTH / 1 + 0.29)' ps='2*int((1 + 2)/2) * (WIDTH / 1 + 0.29)' nrd='0.29 / WIDTH ' nrs='0.29 / WIDTH ' sa=0
+ sb=0 sd=0 mult=1
* noconn B
* noconn G
.ends

* expanding   symbol:  sky130_tests/test_sweep_mos_w.sym # of pins=0
** sym_path: /pdk/sky130A/libs.tech/xschem/sky130_tests/test_sweep_mos_w.sym
** sch_path: /pdk/sky130A/libs.tech/xschem/sky130_tests/test_sweep_mos_w.sch
.subckt test_sweep_mos_w
V1 G GND 1
V2 D GND 1.8
**** begin user architecture code
.lib /pdk/sky130A/libs.tech/combined/sky130.lib.spice tt
**** end user architecture code
**** begin user architecture code

* ngspice commands
.param WN=1
.options savecurrents
.include test_sweep_mos_w.save
.dc v2 0 1.8 0.01
.control
  let start_w = 1
  let stop_w = 90
  let delta_w = 5
  let w_act = start_w
  let new_vth = 0.3
  while w_act le stop_w
    alterparam WN = $&w_act
    reset
    ** example for changing a model param
    * altermod @m.xm1.msky130_fd_pr__nfet_01v8[vth0]=$&new_vth
    save all
    save @m.xm1.msky130_fd_pr__nfet_01v8[gm]
    save @m.xm1.msky130_fd_pr__nfet_01v8[W]
    run
    remzerovec
    write test_sweep_mos_w.raw
    let w_act = w_act + delta_w
    set appendwrite
  end
.endc

**** end user architecture code
XM1 D G GND GND sky130_fd_pr__nfet_01v8 L=0.15 W=WN nf=1 ad='int((1 + 1)/2) * WN / 1 * 0.29' as='int((1 + 2)/2) * WN / 1 * 0.29' pd='2*int((1 + 1)/2) * (WN / 1 + 0.29)'
+ ps='2*int((1 + 2)/2) * (WN / 1 + 0.29)' nrd='0.29 / WN ' nrs='0.29 / WN ' sa=0 sb=0 sd=0 mult=1
.ends

* expanding   symbol:  sky130_tests/tb_bandgap_opamp.sym # of pins=0
** sym_path: /pdk/sky130A/libs.tech/xschem/sky130_tests/tb_bandgap_opamp.sym
** sch_path: /pdk/sky130A/libs.tech/xschem/sky130_tests/tb_bandgap_opamp.sch
.subckt tb_bandgap_opamp
*.ipin VCC
*.ipin START
*.ipin PLUS
*.opin OUT
*.ipin MINUS
*.ipin EN_N
x6 ADJ DIFFOUT_N START START_N VCC VSS passgate_1 W_N=0.42 L_N=0.3 W_P=0.7 L_P=0.35
XC1 ADJ VSS sky130_fd_pr__cap_mim_m3_2 W=9 L=9 MF=2 m=2
x2 START_N START VCC VSS not W_N=1 L_N=0.15 W_P=2 L_P=0.15
x1 EN_N MINUS PLUS DIFFOUT_N VCC VSS ADJ zero_opamp
XM18 VTH1 VTH1 VSS VSS sky130_fd_pr__nfet_01v8 L=0.15 W=0.5 nf=1 ad=0.145 as=0.145 pd=1.58 ps=1.58 nrd=0.58 nrs=0.58 sa=0 sb=0
+ sd=0 mult=1
I0 VSS VTH1 100n
x3 DIFFOUT_N OUT VCC VSS START_N START EN_N gain_stage2 WN=0.5 WP=1 wcap=9
E5 TEMPERAT VSS VOL=' temper '
* noconn TEMPERAT
* noconn EN_N
* noconn MINUS
* noconn PLUS
* noconn START
* noconn VCC
XM1 VTH2 VTH2 VSS VSS sky130_fd_pr__nfet_01v8 L=0.15 W=0.5 nf=1 ad=0.145 as=0.145 pd=1.58 ps=1.58 nrd=0.58 nrs=0.58 sa=0 sb=0 sd=0
+ mult=1
I1 VSS VTH2 100n
.ends

* expanding   symbol:  sky130_tests/tb_charge_pump.sym # of pins=0
** sym_path: /pdk/sky130A/libs.tech/xschem/sky130_tests/tb_charge_pump.sym
** sch_path: /pdk/sky130A/libs.tech/xschem/sky130_tests/tb_charge_pump.sch
.subckt tb_charge_pump
x1 net4 HV A B C D charge_pump
x2 A B C CK D net4 charge_pump_phasegen
V1 VCC GND 'VCC'
V2 CK GND pulse 0 {VCC} 0 100p 100p {PER/2-0.1n} {PER}
C1 HV GND 15p
I0 net5 GND pwl 0 0 1u 0 1.01u 100u 2u 100u 2.01u 150u 3u 150u 3.01u 200u 4u 200u 4.01u 250u
Vload HV net5 0
.save i(vload)
x3 net3 HV2 CK CKN charge_pump2
V3 CKN GND pulse {VCC} 0 0 100p 100p {PER/2-0.1n} {PER}
C2 HV2 GND 15p
I1 net6 GND pwl 0 0 1u 0 1.01u 100u 2u 100u 2.01u 150u 3u 150u 3.01u 200u 4u 200u 4.01u 250u
Vload1 HV_IDEAL net7 0
.save i(vload1)
* noconn GND
C3 HV_IDEAL GND 15p
Vload2 HV2 net6 0
.save i(vload2)
x7 net2 HV_IDEAL CK CKN charge_pump_ideal
I2 net7 GND pwl 0 0 1u 0 1.01u 100u 2u 100u 2.01u 150u 3u 150u 3.01u 200u 4u 200u 4.01u 250u
V4 net1 GND pwl 0 {VCC} 1n {3*VCC}
R1 HV_IDEAL2 net1 {2/1.82p/FREQ}
C4 HV_IDEAL2 GND 15p
Vload3 HV_IDEAL2 net8 0
.save i(vload3)
I3 net8 GND pwl 0 0 1u 0 1.01u 100u 2u 100u 2.01u 150u 3u 150u 3.01u 200u 4u 200u 4.01u 250u
Vid VCC net2 0
.save i(vid)
Vcp2 VCC net3 0
.save i(vcp2)
Vcp VCC net4 0
.save i(vcp)
.ends

* expanding   symbol:  sky130_tests/cmos_ac_sweep.sym # of pins=0
** sym_path: /pdk/sky130A/libs.tech/xschem/sky130_tests/cmos_ac_sweep.sym
** sch_path: /pdk/sky130A/libs.tech/xschem/sky130_tests/cmos_ac_sweep.sch
.subckt cmos_ac_sweep
VVCC VCC 0 'VDD'
IBIAS 0 GN 10u
CL DIFFOUT 0 2p
Vright DIFFOUT net2 0
.save i(vright)
V3 PLUS MINUS dc 0 ac 1 0
V2 MINUS 0 'VCM'
XM7 DIFFOUT G VCC VCC sky130_fd_pr__pfet_01v8_lvt L=2 W=5 nf=1 ad=1.45 as=1.45 pd=10.58 ps=10.58 nrd=0.058 nrs=0.058 sa=0 sb=0
+ sd=0 mult=1
XM2 G G VCC VCC sky130_fd_pr__pfet_01v8_lvt L=2 W=5 nf=1 ad=1.45 as=1.45 pd=10.58 ps=10.58 nrd=0.058 nrs=0.058 sa=0 sb=0 sd=0
+ mult=1
XM6 net3 PLUS net1 0 sky130_fd_pr__nfet_01v8_lvt L=0.5 W=2 nf=1 ad=0.58 as=0.58 pd=4.58 ps=4.58 nrd=0.145 nrs=0.145 sa=0 sb=0 sd=0
+ mult=1
XM4 net2 MINUS net1 0 sky130_fd_pr__nfet_01v8_lvt L=0.5 W=2 nf=1 ad=0.58 as=0.58 pd=4.58 ps=4.58 nrd=0.145 nrs=0.145 sa=0 sb=0
+ sd=0 mult=1
XM1 net4 GN 0 0 sky130_fd_pr__nfet_01v8 L=2 W=4 nf=1 ad=1.16 as=1.16 pd=8.58 ps=8.58 nrd=0.0725 nrs=0.0725 sa=0 sb=0 sd=0 mult=1
XM3 GN GN 0 0 sky130_fd_pr__nfet_01v8 L=2 W=4 nf=1 ad=1.16 as=1.16 pd=8.58 ps=8.58 nrd=0.0725 nrs=0.0725 sa=0 sb=0 sd=0 mult=1
Vtail net1 net4 0
.save i(vtail)
Vleft G net3 0
.save i(vleft)
.ends

* expanding   symbol:  sky130_tests/test_hvl_cells.sym # of pins=0
** sym_path: /pdk/sky130A/libs.tech/xschem/sky130_tests/test_hvl_cells.sym
** sch_path: /pdk/sky130A/libs.tech/xschem/sky130_tests/test_hvl_cells.sch
.subckt test_hvl_cells
VVCC VCC 0 pwl 0 0 3n 5
x1 CK DATA RST_B 0 0 VCC VCC Q sky130_fd_sc_hvl__dfrtp_1
x2 DATA Q 0 0 VCC VCC OUT sky130_fd_sc_hvl__and2_1
VCK CK 0 pulse 0 5 30n 0.2n 0.2n 10n 20n
VDATA DATA 0 pulse 0 5 20n 0.2n 0.2n 100n 200n
VRST_B RST_B 0 pwl 0 0 10n 0 10.2n 5
* noconn VCC
* noconn OUT
.ends

* expanding   symbol:  sky130_tests/test_short_option.sym # of pins=0
** sym_path: /pdk/sky130A/libs.tech/xschem/sky130_tests/test_short_option.sym
** sch_path: /pdk/sky130A/libs.tech/xschem/sky130_tests/test_short_option.sch
.subckt test_short_option
*.iopin NET_A
*.iopin NET_C
* short x2 : NET_A <--> NET_A
* short x5 : #net1 <--> #net1
* short x1 : NET_E <--> NET_E
x10 NET_E NET_B NET_E VCC VSS lvnand WidthN=1 LenN=0.15 WidthP=1 LenP=0.15
x12 net1 net1 VCC VSS not W_N=0.5 L_N=1 W_P=1 L_P=1
x3 NET_A NET_A VCC VSS not W_N=0.5 L_N=1 W_P=1 L_P=1
x6 NET_E net1 VCC VSS not W_N=0.5 L_N=1 W_P=1 L_P=1
x7 NET_B NET_A VCC VSS not W_N=0.5 L_N=1 W_P=1 L_P=1
x4 net2 NET_B VCC VSS not W_N=0.5 L_N=1 W_P=1 L_P=1
x8 NET_F net2 VCC VSS not W_N=0.5 L_N=1 W_P=1 L_P=1
Vopt1 NET_D net1 0
.save i(vopt1)
Vopt2 NET_C net1 0
.save i(vopt2)
.ends

* expanding   symbol:  sky130_tests/test_lvs_ignore.sym # of pins=0
** sym_path: /pdk/sky130A/libs.tech/xschem/sky130_tests/test_lvs_ignore.sym
** sch_path: /pdk/sky130A/libs.tech/xschem/sky130_tests/test_lvs_ignore.sch
.subckt test_lvs_ignore
x5 net3 net1 VCC VSS not W_N=0.5 L_N=1 W_P=1 L_P=1
V2 net1 GND 0
R1 VDD net2 100MEG
C1 net2 GND 1p
R3 VDD net1 100MEG
x1 STARTUP net2 VCC VSS not W_N=0.5 L_N=1 W_P=1 L_P=1
.ends

* expanding   symbol:  sky130_tests/test_generators.sym # of pins=0
** sym_path: /pdk/sky130A/libs.tech/xschem/sky130_tests/test_generators.sym
** sch_path: /pdk/sky130A/libs.tech/xschem/sky130_tests/test_generators.sch
.subckt test_generators
R1 VDD VSS 1k
C1 net1 VSS 1p
C2 VDD VSS 1p
R2 VDD net1 100
* shorted: R3  VDD <--> VDD 0.1
.ends

* expanding   symbol:  sky130_tests/optimize_delay.sym # of pins=0
** sym_path: /pdk/sky130A/libs.tech/xschem/sky130_tests/optimize_delay.sym
** sch_path: /pdk/sky130A/libs.tech/xschem/sky130_tests/optimize_delay.sch
.subckt optimize_delay
V1 VCC GND {VCC}
V2 CK GND pulse 0 {VCC} 0 100p 100p {PER/2-0.1n} {PER}
* noconn GND
C1 net3 0 4f
C2 net1 0 4f
C3 net2 0 4f
x4 net3 CK VCC GND not W_N=3.5 L_N=0.15 W_P=7.0 L_P=0.15
x1 net1 net3 VCC GND not W_N=3.5 L_N=0.15 W_P=7.0 L_P=0.15
x2 net2 net1 VCC GND not W_N=3.5 L_N=0.15 W_P=7.0 L_P=0.15
x3 CK_DEL net2 VCC GND not W_N=3.5 L_N=0.15 W_P=7.0 L_P=0.15
C4 CK_DEL 0 100f
.ends

* expanding   symbol:  sky130_tests/test_customplot.sym # of pins=0
** sym_path: /pdk/sky130A/libs.tech/xschem/sky130_tests/test_customplot.sym
** sch_path: /pdk/sky130A/libs.tech/xschem/sky130_tests/test_customplot.sch
.subckt test_customplot
V1 A 0 dc 3 pwl 0 0 1n 3
C1 B 0 10p
**** begin user architecture code

.param W=2
.options save all
.control
  save all
  let start=2
  let step=1
  let current=start
  let index=0
  let points=10
  ** Create a new plot and store in myplot its name. We create
  ** vectors in this plot namespace
  setplot new
  set myplot=$curplot
  let del=vector(points)
  let w=vector(points)
  while index < points
    alterparam W=$&current
    reset
    op
    write test_customplot.raw
    set appendwrite
    tran 0.1n 500n uic
    meas tran tdiff TRIG v(a) VAL=1.5 RISE=1 TARG v(b) VAL=2.5 RISE=1
    ** specify myplot namespace to reference vectors
    let {$myplot}.del[index] = tdiff
    let {$myplot}.w[index] = current
    let current = current + step
    write test_customplot.raw
    let current = current + step
    let index = index + 1
  end
  unset appendwrite
  ** go back to myplot, define axes and units, write data
  setplot $myplot
  deftype v width W
  settype width w
  settype time del
  setscale w
  * setcs curplotname = "DC transfer characteristic"
  setcs curplotname = "foo"
  setcs curplottitle = "Delay vs width"
  write delay.raw
.endc

**** end user architecture code
XM1 B 0 A VCC sky130_fd_pr__pfet_g5v0d10v5 L=1 W=W nf=1 ad='int((1 + 1)/2) * W / 1 * 0.29' as='int((1 + 2)/2) * W / 1 * 0.29' pd='2*int((1 + 1)/2) * (W / 1 + 0.29)'
+ ps='2*int((1 + 2)/2) * (W / 1 + 0.29)' nrd='0.29 / W ' nrs='0.29 / W ' sa=0 sb=0 sd=0 mult=1
V2 VCC 0 3
R1 B 0 100k
.ends

* expanding   symbol:  devices/intuitive_interface_cheatsheet.sym # of pins=0
** sym_path: /opt/ref/share/xschem/xschem_library/devices/intuitive_interface_cheatsheet.sym
** sch_path: /opt/ref/share/xschem/xschem_library/devices/intuitive_interface_cheatsheet.sch
.subckt intuitive_interface_cheatsheet
.ends

* expanding   symbol:  sky130_tests/sky130_oscillator.sym # of pins=0
** sym_path: /pdk/sky130A/libs.tech/xschem/sky130_tests/sky130_oscillator.sym
** sch_path: /pdk/sky130A/libs.tech/xschem/sky130_tests/sky130_oscillator.sch
.subckt sky130_oscillator
*.iopin VSS
*.iopin VCC
*.ipin ENAB
*.opin QB
*.opin Q
x9 RSTBB BB RSTAB VCC VSS lvnand WidthN=0.5 LenN=0.15 WidthP=1 LenP=0.15
x1 RSTAB AB RSTBB VCC VSS lvnand WidthN=0.5 LenN=0.15 WidthP=1 LenP=0.15
XM1 BH RSTB net1 net1 sky130_fd_pr__pfet_01v8 L=0.15 W=4 nf=1 ad=1.16 as=1.16 pd=8.58 ps=8.58 nrd=0.0725 nrs=0.0725 sa=0 sb=0 sd=0
+ mult=1
XM2 B RSTB VSS VSS sky130_fd_pr__nfet_01v8 L=0.15 W=1 nf=1 ad=0.29 as=0.29 pd=2.58 ps=2.58 nrd=0.29 nrs=0.29 sa=0 sb=0 sd=0 mult=1
x2 RSTA RSTAB VCC VSS not W_N=0.5 L_N=0.15 W_P=1 L_P=0.15
x3 RSTB RSTBB VCC VSS not W_N=0.5 L_N=0.15 W_P=1 L_P=0.15
x4 VCC B BB VCC VSS lvnand WidthN=0.5 LenN=1 WidthP=1 LenP=0.3
x5 ENAB A AB VCC VSS lvnand WidthN=0.5 LenN=1 WidthP=1 LenP=0.3
XM3 AH RSTA net2 net2 sky130_fd_pr__pfet_01v8 L=0.15 W=4 nf=1 ad=1.16 as=1.16 pd=8.58 ps=8.58 nrd=0.0725 nrs=0.0725 sa=0 sb=0 sd=0
+ mult=1
XM4 A RSTA VSS VSS sky130_fd_pr__nfet_01v8 L=0.15 W=1 nf=1 ad=0.29 as=0.29 pd=2.58 ps=2.58 nrd=0.29 nrs=0.29 sa=0 sb=0 sd=0 mult=1
x6 Q RSTA VCC VSS not W_N=1 L_N=0.15 W_P=2 L_P=0.15
x7 QB RSTB VCC VSS not W_N=1 L_N=0.15 W_P=2 L_P=0.15
XC2 B VSS sky130_fd_pr__cap_mim_m3_2 W=10 L=10 MF=5 m=5
XC1 A VSS sky130_fd_pr__cap_mim_m3_2 W=10 L=10 MF=5 m=5
XR1 A AH VSS sky130_fd_pr__res_xhigh_po_1p41 L=20 mult=1
XR2 B BH VSS sky130_fd_pr__res_xhigh_po_1p41 L=20 mult=1
VB VCC net1 0
VA VCC net2 0
.ends

* expanding   symbol:  sky130_tests/sky130_mismatch.sym # of pins=0
** sym_path: /pdk/sky130A/libs.tech/xschem/sky130_tests/sky130_mismatch.sym
** sch_path: /pdk/sky130A/libs.tech/xschem/sky130_tests/sky130_mismatch.sch
.subckt sky130_mismatch
XM18 VTH1 VTH1 VSS VSS sky130_fd_pr__nfet_01v8 L=0.15 W=0.5 nf=1 ad=0.145 as=0.145 pd=1.58 ps=1.58 nrd=0.58 nrs=0.58 sa=0 sb=0
+ sd=0 mult=10 m=10
I0 net1 VTH1 100n
XM1[9] VTH2 VTH2 VSS VSS sky130_fd_pr__nfet_01v8 L=0.15 W=0.5 nf=1 ad=0.145 as=0.145 pd=1.58 ps=1.58 nrd=0.58 nrs=0.58 sa=0 sb=0
+ sd=0 mult=1
XM1[8] VTH2 VTH2 VSS VSS sky130_fd_pr__nfet_01v8 L=0.15 W=0.5 nf=1 ad=0.145 as=0.145 pd=1.58 ps=1.58 nrd=0.58 nrs=0.58 sa=0 sb=0
+ sd=0 mult=1
XM1[7] VTH2 VTH2 VSS VSS sky130_fd_pr__nfet_01v8 L=0.15 W=0.5 nf=1 ad=0.145 as=0.145 pd=1.58 ps=1.58 nrd=0.58 nrs=0.58 sa=0 sb=0
+ sd=0 mult=1
XM1[6] VTH2 VTH2 VSS VSS sky130_fd_pr__nfet_01v8 L=0.15 W=0.5 nf=1 ad=0.145 as=0.145 pd=1.58 ps=1.58 nrd=0.58 nrs=0.58 sa=0 sb=0
+ sd=0 mult=1
XM1[5] VTH2 VTH2 VSS VSS sky130_fd_pr__nfet_01v8 L=0.15 W=0.5 nf=1 ad=0.145 as=0.145 pd=1.58 ps=1.58 nrd=0.58 nrs=0.58 sa=0 sb=0
+ sd=0 mult=1
XM1[4] VTH2 VTH2 VSS VSS sky130_fd_pr__nfet_01v8 L=0.15 W=0.5 nf=1 ad=0.145 as=0.145 pd=1.58 ps=1.58 nrd=0.58 nrs=0.58 sa=0 sb=0
+ sd=0 mult=1
XM1[3] VTH2 VTH2 VSS VSS sky130_fd_pr__nfet_01v8 L=0.15 W=0.5 nf=1 ad=0.145 as=0.145 pd=1.58 ps=1.58 nrd=0.58 nrs=0.58 sa=0 sb=0
+ sd=0 mult=1
XM1[2] VTH2 VTH2 VSS VSS sky130_fd_pr__nfet_01v8 L=0.15 W=0.5 nf=1 ad=0.145 as=0.145 pd=1.58 ps=1.58 nrd=0.58 nrs=0.58 sa=0 sb=0
+ sd=0 mult=1
XM1[1] VTH2 VTH2 VSS VSS sky130_fd_pr__nfet_01v8 L=0.15 W=0.5 nf=1 ad=0.145 as=0.145 pd=1.58 ps=1.58 nrd=0.58 nrs=0.58 sa=0 sb=0
+ sd=0 mult=1
XM1[0] VTH2 VTH2 VSS VSS sky130_fd_pr__nfet_01v8 L=0.15 W=0.5 nf=1 ad=0.145 as=0.145 pd=1.58 ps=1.58 nrd=0.58 nrs=0.58 sa=0 sb=0
+ sd=0 mult=1
V1 VSS net1 0
.save i(v1)
I1 VSS VTH2 100n
.ends

* expanding   symbol:  sky130_tests/test_sweep_res_l.sym # of pins=0
** sym_path: /pdk/sky130A/libs.tech/xschem/sky130_tests/test_sweep_res_l.sym
** sch_path: /pdk/sky130A/libs.tech/xschem/sky130_tests/test_sweep_res_l.sch
.subckt test_sweep_res_l
V2 D GND 1.8
**** begin user architecture code
.lib /pdk/sky130A/libs.tech/combined/sky130.lib.spice tt
**** end user architecture code
**** begin user architecture code

* ngspice commands
.param L=1
.options savecurrents
.control
  let start_l = 1
  let stop_l = 10
  let delta_l = 1
  let l_act = start_l
  while l_act le stop_l
    alterparam L = $&l_act
    reset
    save all
    op
    remzerovec
    write test_sweep_res_l.raw
    let l_act = l_act + delta_l
    set appendwrite
  end
.endc

**** end user architecture code
XR1 GND D GND sky130_fd_pr__res_high_po_0p69 L={L} mult=1
.ends

* expanding   symbol:  sky130_tests/tb_diff_amp.sym # of pins=0
** sym_path: /pdk/sky130A/libs.tech/xschem/sky130_tests/tb_diff_amp.sym
** sch_path: /pdk/sky130A/libs.tech/xschem/sky130_tests/tb_diff_amp.sch
.subckt tb_diff_amp
XU1 Z A B diff_amp_cell
V1 A 0 3.1
V2 B 0 3
**** begin user architecture code

.options savecurrents
.control
  save all
  op
  remzerovec
  write tb_diff_amp.raw
  dc V1 0 6 0.01
  set appendwrite
  remzerovec
  write tb_diff_amp.raw
  quit 0
.endc

**** end user architecture code
.ends

* expanding   symbol:  sky130_tests/montecarlo_mismatch_sim.sym # of pins=0
** sym_path: /pdk/sky130A/libs.tech/xschem/sky130_tests/montecarlo_mismatch_sim.sym
** sch_path: /pdk/sky130A/libs.tech/xschem/sky130_tests/montecarlo_mismatch_sim.sch
.subckt montecarlo_mismatch_sim
Vprobe2 net1 VM 0
VICM VCM GND dc 0.85 ac 0
C1 net1 GND 5p
V3 VDD GND 1.8
**** begin user architecture code

.options savecurrents
.control
 let runs=1000
 let r=0
 dowhile r < runs
   reset
   op
   let vdiff = v(vm,vcm)
   let run=r
   remzerovec
   write montecarlo_mismatch_sim.raw
   set appendwrite
   print v(vm,vcm)
   let r = r + 1
 end
.endc

**** end user architecture code
x2 VDD VM VCM net1 GND ota1tb
.save v(vm)
.save v(vcm)
.ends

* expanding   symbol:  sky130_tests/not.sym # of pins=2
** sym_path: /pdk/sky130A/libs.tech/xschem/sky130_tests/not.sym
** sch_path: /pdk/sky130A/libs.tech/xschem/sky130_tests/not.sch
.subckt not y a VCCPIN VSSPIN     W_N=1 L_N=0.15 W_P=2 L_P=0.15
*.opin y
*.ipin a
XM1 DN a VSSPIN VSSPIN sky130_fd_pr__nfet_01v8 L=L_N W=W_N nf=1 ad='int((1 + 1)/2) * W_N / 1 * 0.29' as='int((1 + 2)/2) * W_N / 1 * 0.29'
+ pd='2*int((1 + 1)/2) * (W_N / 1 + 0.29)' ps='2*int((1 + 2)/2) * (W_N / 1 + 0.29)' nrd='0.29 / W_N ' nrs='0.29 / W_N ' sa=0 sb=0 sd=0
+ mult=1
XM2 DP a VCCPIN VCCPIN sky130_fd_pr__pfet_01v8 L=L_P W=W_P nf=1 ad='int((1 + 1)/2) * W_P / 1 * 0.29' as='int((1 + 2)/2) * W_P / 1 * 0.29'
+ pd='2*int((1 + 1)/2) * (W_P / 1 + 0.29)' ps='2*int((1 + 2)/2) * (W_P / 1 + 0.29)' nrd='0.29 / W_P ' nrs='0.29 / W_P ' sa=0 sb=0 sd=0
+ mult=1
Vmeas DP y 0
.save i(vmeas)
Vmeas1 y DN 0
.save i(vmeas1)
.save v(dp)
.save v(dn)
.ends

* expanding   symbol:  sky130_tests/lvtnot.sym # of pins=2
** sym_path: /pdk/sky130A/libs.tech/xschem/sky130_tests/lvtnot.sym
** sch_path: /pdk/sky130A/libs.tech/xschem/sky130_tests/lvtnot.sch
.subckt lvtnot a y VCCPIN VSSPIN     W_N=1 L_N=0.15 W_P=2 L_P=0.35
*.opin y
*.ipin a
XM2 y a VCCPIN VCCPIN sky130_fd_pr__pfet_01v8_lvt L=L_P W=W_P nf=1 ad='int((1 + 1)/2) * W_P / 1 * 0.29' as='int((1 + 2)/2) * W_P / 1 * 0.29'
+ pd='2*int((1 + 1)/2) * (W_P / 1 + 0.29)' ps='2*int((1 + 2)/2) * (W_P / 1 + 0.29)' nrd='0.29 / W_P ' nrs='0.29 / W_P ' sa=0 sb=0 sd=0
+ mult=1
XM1 y a VSSPIN VSSPIN sky130_fd_pr__nfet_01v8_lvt L=L_N W=W_N nf=1 ad='int((1 + 1)/2) * W_N / 1 * 0.29' as='int((1 + 2)/2) * W_N / 1 * 0.29'
+ pd='2*int((1 + 1)/2) * (W_N / 1 + 0.29)' ps='2*int((1 + 2)/2) * (W_N / 1 + 0.29)' nrd='0.29 / W_N ' nrs='0.29 / W_N ' sa=0 sb=0 sd=0
+ mult=1
.ends

* expanding   symbol:  sky130_tests/passgate.sym # of pins=4
** sym_path: /pdk/sky130A/libs.tech/xschem/sky130_tests/passgate.sym
** sch_path: /pdk/sky130A/libs.tech/xschem/sky130_tests/passgate.sch
.subckt passgate Z A GP GN VCCBPIN VSSBPIN  W_N=1 L_N=0.2 W_P=1 L_P=0.2

*.iopin A
*.iopin Z
*.ipin GP
*.ipin GN
XM1 Z GN A VSSBPIN sky130_fd_pr__nfet_01v8 L=L_N W=W_N nf=1 ad='int((1 + 1)/2) * W_N / 1 * 0.29' as='int((1 + 2)/2) * W_N / 1 * 0.29'
+ pd='2*int((1 + 1)/2) * (W_N / 1 + 0.29)' ps='2*int((1 + 2)/2) * (W_N / 1 + 0.29)' nrd='0.29 / W_N ' nrs='0.29 / W_N ' sa=0 sb=0 sd=0
+ mult=1
XM2 Z GP A VCCBPIN sky130_fd_pr__pfet_01v8 L=L_P W=W_P nf=1 ad='int((1 + 1)/2) * W_P / 1 * 0.29' as='int((1 + 2)/2) * W_P / 1 * 0.29'
+ pd='2*int((1 + 1)/2) * (W_P / 1 + 0.29)' ps='2*int((1 + 2)/2) * (W_P / 1 + 0.29)' nrd='0.29 / W_P ' nrs='0.29 / W_P ' sa=0 sb=0 sd=0
+ mult=1
* noconn VCCBPIN
* noconn VSSBPIN
.ends

* expanding   symbol:  sky130_tests/stdcells.sym # of pins=11
** sym_path: /pdk/sky130A/libs.tech/xschem/sky130_tests/stdcells.sym
** sch_path: /pdk/sky130A/libs.tech/xschem/sky130_tests/stdcells.sch
.subckt stdcells QLATCH A X B Y CLK Q RESET_B XSCHEM VCC VSS
*.ipin RESET_B
*.ipin CLK
*.ipin B
*.ipin A
*.opin Y
*.opin X
*.opin QLATCH
*.opin Q
*.opin XSCHEM
*.ipin VCC
*.ipin VSS
x1 A B VSS VSS VCC VCC IX sky130_fd_sc_hd__nand2_1
C1 IX 0 3f
x2 CLK A RESET_B VSS VSS VCC VCC IQ sky130_fd_sc_hd__dfrtp_1
C2 IQ 0 3f
C3 IY 0 3f
x3 A B VSS VSS VCC VCC IY sky130_fd_sc_hd__nor2b_1
x4 A CLK RESET_B VSS VSS VCC VCC IQLATCH net1 sky130_fd_sc_hd__dlrbn_1
C4 IQLATCH 0 3f
x5 IY B VSS VSS VCC VCC net2 sky130_fd_sc_hd__nor2b_1
x6 net2 IQLATCH VSS VSS VCC VCC net4 sky130_fd_sc_hd__nand2_1
x7 net3 net4 IQ RESET_B VSS VSS VCC VCC IXSCHEM sky130_fd_sc_hd__a31o_2
* noconn #net1
* noconn IXSCHEM
x8 IY VSS VSS VCC VCC net3 sky130_fd_sc_hd__inv_2
x13 IY VSS VSS VCC VCC Y sky130_fd_sc_hd__buf_2
x9 IX VSS VSS VCC VCC X sky130_fd_sc_hd__buf_2
x14 IQ VSS VSS VCC VCC Q sky130_fd_sc_hd__buf_2
x15 IQLATCH VSS VSS VCC VCC QLATCH sky130_fd_sc_hd__buf_2
x11 IXSCHEM VSS VSS VCC VCC XSCHEM sky130_fd_sc_hd__buf_2
C5 net2 0 3f
C6 net3 0 3f
C7 IXSCHEM 0 3f
C8 RESET_B 0 3f
C9 net4 0 3f
.ends

* expanding   symbol:  sky130_tests/stdcells_xspice.sym # of pins=11
** sym_path: /pdk/sky130A/libs.tech/xschem/sky130_tests/stdcells_xspice.sym
** sch_path: /pdk/sky130A/libs.tech/xschem/sky130_tests/stdcells_xspice.sch
.subckt stdcells_xspice QLATCH A X B Y CLK Q RESET_B XSCHEM VCC VSS
*.ipin RESET_B
*.ipin CLK
*.ipin B
*.ipin A
*.opin Y
*.opin X
*.opin QLATCH
*.opin Q
*.opin XSCHEM
*.ipin VCC
*.ipin VSS
**** begin user architecture code

A1 [A B] IX d_lut_sky130_fd_sc_hd__nand2_1
A2 A CLK NULL ~RESET_B IQ NULL ddflop
A3 [A B] IY d_lut_sky130_fd_sc_hd__nor2b_1
A4 A ~CLK NULL ~RESET_B IQLATCH net1 dlatch
A5 [IY B] net2 d_lut_sky130_fd_sc_hd__nor2b_1
A6 [net2 IQLATCH] net4 d_lut_sky130_fd_sc_hd__nand2_1
A7 [net3 net4 IQ RESET_B] IXSCHEM d_lut_sky130_fd_sc_hd__a31o_2
A8 [IY] net3 d_lut_sky130_fd_sc_hd__inv_2
A13 [IY] Y d_lut_sky130_fd_sc_hd__buf_2
A9 [IX] X d_lut_sky130_fd_sc_hd__buf_2
A14 [IQ] Q d_lut_sky130_fd_sc_hd__buf_2
A15 [IQLATCH] QLATCH d_lut_sky130_fd_sc_hd__buf_2
A11 [IXSCHEM] XSCHEM d_lut_sky130_fd_sc_hd__buf_2

**** end user architecture code
* noconn A
* noconn B
* noconn CLK
* noconn RESET_B
* noconn VCC
* noconn VSS
* noconn QLATCH
* noconn X
* noconn Y
* noconn Q
* noconn XSCHEM
.ends

* expanding   symbol:  mips_cpu/top.sym # of pins=2
** sym_path: /pdk/sky130A/libs.tech/xschem/mips_cpu/top.sym
** sch_path: /pdk/sky130A/libs.tech/xschem/mips_cpu/top.sch
.subckt top clk reset
*.ipin clk
*.ipin reset
xmips_inst imem_addr[31] imem_addr[30] imem_addr[29] imem_addr[28] imem_addr[27] imem_addr[26] imem_addr[25] imem_addr[24]
+ imem_addr[23] imem_addr[22] imem_addr[21] imem_addr[20] imem_addr[19] imem_addr[18] imem_addr[17] imem_addr[16] imem_addr[15] imem_addr[14]
+ imem_addr[13] imem_addr[12] imem_addr[11] imem_addr[10] imem_addr[9] imem_addr[8] imem_addr[7] imem_addr[6] imem_addr[5] imem_addr[4]
+ imem_addr[3] imem_addr[2] imem_addr[1] imem_addr[0] clk dmem_we reset imem_data[31] imem_data[30] imem_data[29] imem_data[28] imem_data[27]
+ imem_data[26] imem_data[25] imem_data[24] imem_data[23] imem_data[22] imem_data[21] imem_data[20] imem_data[19] imem_data[18] imem_data[17]
+ imem_data[16] imem_data[15] imem_data[14] imem_data[13] imem_data[12] imem_data[11] imem_data[10] imem_data[9] imem_data[8] imem_data[7]
+ imem_data[6] imem_data[5] imem_data[4] imem_data[3] imem_data[2] imem_data[1] imem_data[0] dmem_addr[31] dmem_addr[30] dmem_addr[29]
+ dmem_addr[28] dmem_addr[27] dmem_addr[26] dmem_addr[25] dmem_addr[24] dmem_addr[23] dmem_addr[22] dmem_addr[21] dmem_addr[20] dmem_addr[19]
+ dmem_addr[18] dmem_addr[17] dmem_addr[16] dmem_addr[15] dmem_addr[14] dmem_addr[13] dmem_addr[12] dmem_addr[11] dmem_addr[10] dmem_addr[9]
+ dmem_addr[8] dmem_addr[7] dmem_addr[6] dmem_addr[5] dmem_addr[4] dmem_addr[3] dmem_addr[2] dmem_addr[1] dmem_addr[0] dmem_rdata[31]
+ dmem_rdata[30] dmem_rdata[29] dmem_rdata[28] dmem_rdata[27] dmem_rdata[26] dmem_rdata[25] dmem_rdata[24] dmem_rdata[23] dmem_rdata[22]
+ dmem_rdata[21] dmem_rdata[20] dmem_rdata[19] dmem_rdata[18] dmem_rdata[17] dmem_rdata[16] dmem_rdata[15] dmem_rdata[14] dmem_rdata[13]
+ dmem_rdata[12] dmem_rdata[11] dmem_rdata[10] dmem_rdata[9] dmem_rdata[8] dmem_rdata[7] dmem_rdata[6] dmem_rdata[5] dmem_rdata[4] dmem_rdata[3]
+ dmem_rdata[2] dmem_rdata[1] dmem_rdata[0] dmem_wdata[31] dmem_wdata[30] dmem_wdata[29] dmem_wdata[28] dmem_wdata[27] dmem_wdata[26]
+ dmem_wdata[25] dmem_wdata[24] dmem_wdata[23] dmem_wdata[22] dmem_wdata[21] dmem_wdata[20] dmem_wdata[19] dmem_wdata[18] dmem_wdata[17]
+ dmem_wdata[16] dmem_wdata[15] dmem_wdata[14] dmem_wdata[13] dmem_wdata[12] dmem_wdata[11] dmem_wdata[10] dmem_wdata[9] dmem_wdata[8]
+ dmem_wdata[7] dmem_wdata[6] dmem_wdata[5] dmem_wdata[4] dmem_wdata[3] dmem_wdata[2] dmem_wdata[1] dmem_wdata[0] mips
xdmem_inst clk dmem_we dmem_rdata[31] dmem_rdata[30] dmem_rdata[29] dmem_rdata[28] dmem_rdata[27] dmem_rdata[26] dmem_rdata[25]
+ dmem_rdata[24] dmem_rdata[23] dmem_rdata[22] dmem_rdata[21] dmem_rdata[20] dmem_rdata[19] dmem_rdata[18] dmem_rdata[17] dmem_rdata[16]
+ dmem_rdata[15] dmem_rdata[14] dmem_rdata[13] dmem_rdata[12] dmem_rdata[11] dmem_rdata[10] dmem_rdata[9] dmem_rdata[8] dmem_rdata[7]
+ dmem_rdata[6] dmem_rdata[5] dmem_rdata[4] dmem_rdata[3] dmem_rdata[2] dmem_rdata[1] dmem_rdata[0] dmem_addr[31] dmem_addr[30] dmem_addr[29]
+ dmem_addr[28] dmem_addr[27] dmem_addr[26] dmem_addr[25] dmem_addr[24] dmem_addr[23] dmem_addr[22] dmem_addr[21] dmem_addr[20] dmem_addr[19]
+ dmem_addr[18] dmem_addr[17] dmem_addr[16] dmem_addr[15] dmem_addr[14] dmem_addr[13] dmem_addr[12] dmem_addr[11] dmem_addr[10] dmem_addr[9]
+ dmem_addr[8] dmem_addr[7] dmem_addr[6] dmem_addr[5] dmem_addr[4] dmem_addr[3] dmem_addr[2] dmem_addr[1] dmem_addr[0] dmem_wdata[31]
+ dmem_wdata[30] dmem_wdata[29] dmem_wdata[28] dmem_wdata[27] dmem_wdata[26] dmem_wdata[25] dmem_wdata[24] dmem_wdata[23] dmem_wdata[22]
+ dmem_wdata[21] dmem_wdata[20] dmem_wdata[19] dmem_wdata[18] dmem_wdata[17] dmem_wdata[16] dmem_wdata[15] dmem_wdata[14] dmem_wdata[13]
+ dmem_wdata[12] dmem_wdata[11] dmem_wdata[10] dmem_wdata[9] dmem_wdata[8] dmem_wdata[7] dmem_wdata[6] dmem_wdata[5] dmem_wdata[4] dmem_wdata[3]
+ dmem_wdata[2] dmem_wdata[1] dmem_wdata[0] dmem
ximem_inst imem_data[31] imem_data[30] imem_data[29] imem_data[28] imem_data[27] imem_data[26] imem_data[25] imem_data[24]
+ imem_data[23] imem_data[22] imem_data[21] imem_data[20] imem_data[19] imem_data[18] imem_data[17] imem_data[16] imem_data[15] imem_data[14]
+ imem_data[13] imem_data[12] imem_data[11] imem_data[10] imem_data[9] imem_data[8] imem_data[7] imem_data[6] imem_data[5] imem_data[4]
+ imem_data[3] imem_data[2] imem_data[1] imem_data[0] imem_addr[7] imem_addr[6] imem_addr[5] imem_addr[4] imem_addr[3] imem_addr[2] imem
* noconn imem_addr[31:0]
.ends

* expanding   symbol:  sky130_tests/srlatch.sym # of pins=5
** sym_path: /pdk/sky130A/libs.tech/xschem/sky130_tests/srlatch.sym
** sch_path: /pdk/sky130A/libs.tech/xschem/sky130_tests/srlatch.sch
.subckt srlatch S CLK R Q QN
*.ipin S
*.ipin R
*.opin Q
*.opin QN
*.ipin CLK
x5 S CLK SN VCC VSS lvnand WidthN=1 LenN=0.15 WidthP=1 LenP=0.15
x1 R CLK RN VCC VSS lvnand WidthN=1 LenN=0.15 WidthP=1 LenP=0.15
x2 RN Q QN VCC VSS lvnand WidthN=1 LenN=0.15 WidthP=1 LenP=0.15
x3 SN QN Q VCC VSS lvnand WidthN=1 LenN=0.15 WidthP=1 LenP=0.15
.ends

* expanding   symbol:  sky130_tests/n_diffamp.sym # of pins=4
** sym_path: /pdk/sky130A/libs.tech/xschem/sky130_tests/n_diffamp.sym
** sch_path: /pdk/sky130A/libs.tech/xschem/sky130_tests/n_diffamp.sch
.subckt n_diffamp OUT MINUS PLUS NBIAS
*.ipin PLUS
*.ipin MINUS
*.opin OUT
*.ipin NBIAS
XM1 net1 PLUS S GND sky130_fd_pr__nfet_01v8_lvt L=0.3 W=2 nf=1 ad=0.58 as=0.58 pd=4.58 ps=4.58 nrd=0.145 nrs=0.145 sa=0 sb=0 sd=0
+ mult=1
XM2 OUT MINUS S GND sky130_fd_pr__nfet_01v8_lvt L=0.3 W=2 nf=1 ad=0.58 as=0.58 pd=4.58 ps=4.58 nrd=0.145 nrs=0.145 sa=0 sb=0 sd=0
+ mult=1
XM3 OUT net1 VDD VDD sky130_fd_pr__pfet_01v8_lvt L=0.8 W=4 nf=1 ad=1.16 as=1.16 pd=8.58 ps=8.58 nrd=0.0725 nrs=0.0725 sa=0 sb=0
+ sd=0 mult=1
XM4 net1 net1 VDD VDD sky130_fd_pr__pfet_01v8_lvt L=0.8 W=4 nf=1 ad=1.16 as=1.16 pd=8.58 ps=8.58 nrd=0.0725 nrs=0.0725 sa=0 sb=0
+ sd=0 mult=1
XM5 net2 NBIAS GND GND sky130_fd_pr__nfet_01v8 L=2 W=0.7 nf=1 ad=0.203 as=0.203 pd=1.98 ps=1.98 nrd=0.414285714285714
+ nrs=0.414285714285714 sa=0 sb=0 sd=0 mult=1
XR1 GND S GND sky130_fd_pr__res_xhigh_po_0p35 L=50 mult=1
V5 S net2 0
.save i(v5)
.ends

* expanding   symbol:  sky130_tests/bandgap.sym # of pins=6
** sym_path: /pdk/sky130A/libs.tech/xschem/sky130_tests/bandgap.sym
** sch_path: /pdk/sky130A/libs.tech/xschem/sky130_tests/bandgap.sch
.subckt bandgap START CLK EN_N VBG VCC VSS
*.ipin EN_N
*.opin VBG
*.ipin VCC
*.ipin VSS
*.ipin CLK
*.ipin START
XQ1 net6 net2 PLUS sky130_fd_pr__pnp_05v5_W0p68L0p68 m=1 mult=1
XQ2 net7 net1 E2 sky130_fd_pr__pnp_05v5_W0p68L0p68 m=20 mult=20
Vc1 net6 VSS 0
.save i(vc1)
Vb1 net2 VSS 0
.save i(vb1)
Vb2 net1 VSS 0
.save i(vb2)
Vc2 net7 VSS 0
.save i(vc2)
x1 EN_N MINUS PLUS VBG VCC VSS ADJ START bandgap_opamp
V1 VBG net8 0
.save i(v1)
V2 VBG net9 0
.save i(v2)
x2 EN_N ZMINUS PLUS net3 VCC VSS ADJ2 zero_opamp
x3 ZMINUS PLUS F2N F2 VCC VSS passgate W_N=0.5 L_N=0.15 W_P=0.5 L_P=0.15
x4 ZMINUS MINUS F1N F1 VCC VSS passgate W_N=0.5 L_N=0.15 W_P=0.5 L_P=0.15
x5 ADJ2 net3 F2N F2 VCC VSS passgate W_N=0.5 L_N=0.35 W_P=0.6 L_P=0.35
x6 ADJ net3 F1N F1 VCC VSS passgate W_N=0.5 L_N=0.35 W_P=0.6 L_P=0.35
x8 CLK net4 net10 VCC VSS lvnand WidthN=1 LenN=0.15 WidthP=1 LenP=0.15
x9 net11 net5 net12 VCC VSS lvnand WidthN=1 LenN=0.15 WidthP=1 LenP=0.15
x10 net11 CLK VCC VSS not W_N=1 L_N=0.15 W_P=2 L_P=0.15
x11 F2 net5 VCC VSS not W_N=1 L_N=0.15 W_P=2 L_P=0.15
x12 net13 net10 VCC VSS not W_N=0.5 L_N=1 W_P=1 L_P=1
x13 net14 net13 VCC VSS not W_N=0.5 L_N=1 W_P=1 L_P=1
x14 net15 net14 VCC VSS not W_N=0.5 L_N=1 W_P=1 L_P=1
x15 net5 net15 VCC VSS not W_N=0.5 L_N=1 W_P=1 L_P=1
x16 net16 net12 VCC VSS not W_N=0.5 L_N=1 W_P=1 L_P=1
x17 net17 net16 VCC VSS not W_N=0.5 L_N=1 W_P=1 L_P=1
x18 net18 net17 VCC VSS not W_N=0.5 L_N=1 W_P=1 L_P=1
x19 net4 net18 VCC VSS not W_N=0.5 L_N=1 W_P=1 L_P=1
x20 F1 net4 VCC VSS not W_N=1 L_N=0.15 W_P=2 L_P=0.15
c2 VBG VSS 5p
x7 ADJ ADJ2 START_N START VCC VSS passgate W_N=0.5 L_N=0.15 W_P=0.5 L_P=0.15
x21 START_N START VCC VSS not W_N=1 L_N=0.15 W_P=2 L_P=0.15
x22 F1N F1 VCC VSS not W_N=1 L_N=0.15 W_P=2 L_P=0.15
x23 F2N F2 VCC VSS not W_N=1 L_N=0.15 W_P=2 L_P=0.15
XC2 ADJ2 VSS sky130_fd_pr__cap_mim_m3_2 W=10 L=10 MF=20 m=20
XC1 ADJ VSS sky130_fd_pr__cap_mim_m3_2 W=10 L=10 MF=20 m=20
.save v(adj2)
.save v(adj)
.save v(f1)
.save v(f2)
.save v(zminus)
.save v(plus)
.save v(minus)
.save v(start_n)
XR12 net19 net9 VSS sky130_fd_pr__res_xhigh_po_1p41 L=20 mult=1
XR1 net20 net19 VSS sky130_fd_pr__res_xhigh_po_1p41 L=20 mult=1
XR2 net21 net20 VSS sky130_fd_pr__res_xhigh_po_1p41 L=20 mult=1
XR3 net22 net21 VSS sky130_fd_pr__res_xhigh_po_1p41 L=20 mult=1
XR4 MINUS net22 VSS sky130_fd_pr__res_xhigh_po_1p41 L=20 mult=1
XR5 net23 net8 VSS sky130_fd_pr__res_xhigh_po_1p41 L=20 mult=1
XR6 net24 net23 VSS sky130_fd_pr__res_xhigh_po_1p41 L=20 mult=1
XR7 net25 net24 VSS sky130_fd_pr__res_xhigh_po_1p41 L=20 mult=1
XR8 net26 net25 VSS sky130_fd_pr__res_xhigh_po_1p41 L=20 mult=1
XR9 PLUS net26 VSS sky130_fd_pr__res_xhigh_po_1p41 L=20 mult=1
XR10 E2 MINUS VSS sky130_fd_pr__res_xhigh_po_1p41 L=20 mult=1
XC3 MINUS VSS sky130_fd_pr__cap_mim_m3_2 W=10 L=10 MF=2 m=2
XC4 PLUS VSS sky130_fd_pr__cap_mim_m3_2 W=10 L=10 MF=2 m=2
.ends

* expanding   symbol:  sky130_tests/lvnand.sym # of pins=3
** sym_path: /pdk/sky130A/libs.tech/xschem/sky130_tests/lvnand.sym
** sch_path: /pdk/sky130A/libs.tech/xschem/sky130_tests/lvnand.sch
.subckt lvnand A B Y VCCPIN VSSPIN  WidthN=1 LenN=0.15 WidthP=1 LenP=0.15
*.ipin A
*.ipin B
*.opin Y
XM1 Y B S VSSPIN sky130_fd_pr__nfet_01v8 L=LenN W=WidthN nf=1 ad='int((1 + 1)/2) * WidthN / 1 * 0.29' as='int((1 + 2)/2) * WidthN / 1 * 0.29'
+ pd='2*int((1 + 1)/2) * (WidthN / 1 + 0.29)' ps='2*int((1 + 2)/2) * (WidthN / 1 + 0.29)' nrd='0.29 / WidthN ' nrs='0.29 / WidthN ' sa=0
+ sb=0 sd=0 mult=1
XM2 Y A VCCPIN VCCPIN sky130_fd_pr__pfet_01v8 L=LenP W=WidthP nf=1 ad='int((1 + 1)/2) * WidthP / 1 * 0.29' as='int((1 + 2)/2) * WidthP / 1 * 0.29'
+ pd='2*int((1 + 1)/2) * (WidthP / 1 + 0.29)' ps='2*int((1 + 2)/2) * (WidthP / 1 + 0.29)' nrd='0.29 / WidthP ' nrs='0.29 / WidthP ' sa=0
+ sb=0 sd=0 mult=1
XM3 Y B VCCPIN VCCPIN sky130_fd_pr__pfet_01v8 L=LenP W=WidthP nf=1 ad='int((1 + 1)/2) * WidthP / 1 * 0.29' as='int((1 + 2)/2) * WidthP / 1 * 0.29'
+ pd='2*int((1 + 1)/2) * (WidthP / 1 + 0.29)' ps='2*int((1 + 2)/2) * (WidthP / 1 + 0.29)' nrd='0.29 / WidthP ' nrs='0.29 / WidthP ' sa=0
+ sb=0 sd=0 mult=1
XM4 S A VSSPIN VSSPIN sky130_fd_pr__nfet_01v8 L=LenN W=WidthN nf=1 ad='int((1 + 1)/2) * WidthN / 1 * 0.29' as='int((1 + 2)/2) * WidthN / 1 * 0.29'
+ pd='2*int((1 + 1)/2) * (WidthN / 1 + 0.29)' ps='2*int((1 + 2)/2) * (WidthN / 1 + 0.29)' nrd='0.29 / WidthN ' nrs='0.29 / WidthN ' sa=0
+ sb=0 sd=0 mult=1
.ends

* expanding   symbol:  sky130_tests/adder_256bit.sym # of pins=7
** sym_path: /pdk/sky130A/libs.tech/xschem/sky130_tests/adder_256bit.sym
** sch_path: /pdk/sky130A/libs.tech/xschem/sky130_tests/adder_256bit.sch
.subckt adder_256bit A[255] A[254] A[253] A[252] A[251] A[250] A[249] A[248] A[247] A[246] A[245] A[244] A[243] A[242] A[241]
+ A[240] A[239] A[238] A[237] A[236] A[235] A[234] A[233] A[232] A[231] A[230] A[229] A[228] A[227] A[226] A[225] A[224] A[223] A[222]
+ A[221] A[220] A[219] A[218] A[217] A[216] A[215] A[214] A[213] A[212] A[211] A[210] A[209] A[208] A[207] A[206] A[205] A[204] A[203]
+ A[202] A[201] A[200] A[199] A[198] A[197] A[196] A[195] A[194] A[193] A[192] A[191] A[190] A[189] A[188] A[187] A[186] A[185] A[184]
+ A[183] A[182] A[181] A[180] A[179] A[178] A[177] A[176] A[175] A[174] A[173] A[172] A[171] A[170] A[169] A[168] A[167] A[166] A[165]
+ A[164] A[163] A[162] A[161] A[160] A[159] A[158] A[157] A[156] A[155] A[154] A[153] A[152] A[151] A[150] A[149] A[148] A[147] A[146]
+ A[145] A[144] A[143] A[142] A[141] A[140] A[139] A[138] A[137] A[136] A[135] A[134] A[133] A[132] A[131] A[130] A[129] A[128] A[127]
+ A[126] A[125] A[124] A[123] A[122] A[121] A[120] A[119] A[118] A[117] A[116] A[115] A[114] A[113] A[112] A[111] A[110] A[109] A[108]
+ A[107] A[106] A[105] A[104] A[103] A[102] A[101] A[100] A[99] A[98] A[97] A[96] A[95] A[94] A[93] A[92] A[91] A[90] A[89] A[88] A[87]
+ A[86] A[85] A[84] A[83] A[82] A[81] A[80] A[79] A[78] A[77] A[76] A[75] A[74] A[73] A[72] A[71] A[70] A[69] A[68] A[67] A[66] A[65]
+ A[64] A[63] A[62] A[61] A[60] A[59] A[58] A[57] A[56] A[55] A[54] A[53] A[52] A[51] A[50] A[49] A[48] A[47] A[46] A[45] A[44] A[43]
+ A[42] A[41] A[40] A[39] A[38] A[37] A[36] A[35] A[34] A[33] A[32] A[31] A[30] A[29] A[28] A[27] A[26] A[25] A[24] A[23] A[22] A[21]
+ A[20] A[19] A[18] A[17] A[16] A[15] A[14] A[13] A[12] A[11] A[10] A[9] A[8] A[7] A[6] A[5] A[4] A[3] A[2] A[1] A[0] S[255] S[254]
+ S[253] S[252] S[251] S[250] S[249] S[248] S[247] S[246] S[245] S[244] S[243] S[242] S[241] S[240] S[239] S[238] S[237] S[236] S[235]
+ S[234] S[233] S[232] S[231] S[230] S[229] S[228] S[227] S[226] S[225] S[224] S[223] S[222] S[221] S[220] S[219] S[218] S[217] S[216]
+ S[215] S[214] S[213] S[212] S[211] S[210] S[209] S[208] S[207] S[206] S[205] S[204] S[203] S[202] S[201] S[200] S[199] S[198] S[197]
+ S[196] S[195] S[194] S[193] S[192] S[191] S[190] S[189] S[188] S[187] S[186] S[185] S[184] S[183] S[182] S[181] S[180] S[179] S[178]
+ S[177] S[176] S[175] S[174] S[173] S[172] S[171] S[170] S[169] S[168] S[167] S[166] S[165] S[164] S[163] S[162] S[161] S[160] S[159]
+ S[158] S[157] S[156] S[155] S[154] S[153] S[152] S[151] S[150] S[149] S[148] S[147] S[146] S[145] S[144] S[143] S[142] S[141] S[140]
+ S[139] S[138] S[137] S[136] S[135] S[134] S[133] S[132] S[131] S[130] S[129] S[128] S[127] S[126] S[125] S[124] S[123] S[122] S[121]
+ S[120] S[119] S[118] S[117] S[116] S[115] S[114] S[113] S[112] S[111] S[110] S[109] S[108] S[107] S[106] S[105] S[104] S[103] S[102]
+ S[101] S[100] S[99] S[98] S[97] S[96] S[95] S[94] S[93] S[92] S[91] S[90] S[89] S[88] S[87] S[86] S[85] S[84] S[83] S[82] S[81] S[80]
+ S[79] S[78] S[77] S[76] S[75] S[74] S[73] S[72] S[71] S[70] S[69] S[68] S[67] S[66] S[65] S[64] S[63] S[62] S[61] S[60] S[59] S[58]
+ S[57] S[56] S[55] S[54] S[53] S[52] S[51] S[50] S[49] S[48] S[47] S[46] S[45] S[44] S[43] S[42] S[41] S[40] S[39] S[38] S[37] S[36]
+ S[35] S[34] S[33] S[32] S[31] S[30] S[29] S[28] S[27] S[26] S[25] S[24] S[23] S[22] S[21] S[20] S[19] S[18] S[17] S[16] S[15] S[14]
+ S[13] S[12] S[11] S[10] S[9] S[8] S[7] S[6] S[5] S[4] S[3] S[2] S[1] S[0] B[255] B[254] B[253] B[252] B[251] B[250] B[249] B[248]
+ B[247] B[246] B[245] B[244] B[243] B[242] B[241] B[240] B[239] B[238] B[237] B[236] B[235] B[234] B[233] B[232] B[231] B[230] B[229]
+ B[228] B[227] B[226] B[225] B[224] B[223] B[222] B[221] B[220] B[219] B[218] B[217] B[216] B[215] B[214] B[213] B[212] B[211] B[210]
+ B[209] B[208] B[207] B[206] B[205] B[204] B[203] B[202] B[201] B[200] B[199] B[198] B[197] B[196] B[195] B[194] B[193] B[192] B[191]
+ B[190] B[189] B[188] B[187] B[186] B[185] B[184] B[183] B[182] B[181] B[180] B[179] B[178] B[177] B[176] B[175] B[174] B[173] B[172]
+ B[171] B[170] B[169] B[168] B[167] B[166] B[165] B[164] B[163] B[162] B[161] B[160] B[159] B[158] B[157] B[156] B[155] B[154] B[153]
+ B[152] B[151] B[150] B[149] B[148] B[147] B[146] B[145] B[144] B[143] B[142] B[141] B[140] B[139] B[138] B[137] B[136] B[135] B[134]
+ B[133] B[132] B[131] B[130] B[129] B[128] B[127] B[126] B[125] B[124] B[123] B[122] B[121] B[120] B[119] B[118] B[117] B[116] B[115]
+ B[114] B[113] B[112] B[111] B[110] B[109] B[108] B[107] B[106] B[105] B[104] B[103] B[102] B[101] B[100] B[99] B[98] B[97] B[96] B[95]
+ B[94] B[93] B[92] B[91] B[90] B[89] B[88] B[87] B[86] B[85] B[84] B[83] B[82] B[81] B[80] B[79] B[78] B[77] B[76] B[75] B[74] B[73]
+ B[72] B[71] B[70] B[69] B[68] B[67] B[66] B[65] B[64] B[63] B[62] B[61] B[60] B[59] B[58] B[57] B[56] B[55] B[54] B[53] B[52] B[51]
+ B[50] B[49] B[48] B[47] B[46] B[45] B[44] B[43] B[42] B[41] B[40] B[39] B[38] B[37] B[36] B[35] B[34] B[33] B[32] B[31] B[30] B[29]
+ B[28] B[27] B[26] B[25] B[24] B[23] B[22] B[21] B[20] B[19] B[18] B[17] B[16] B[15] B[14] B[13] B[12] B[11] B[10] B[9] B[8] B[7] B[6]
+ B[5] B[4] B[3] B[2] B[1] B[0] COUT SG CIN SP
*.ipin
*+ A[255],A[254],A[253],A[252],A[251],A[250],A[249],A[248],A[247],A[246],A[245],A[244],A[243],A[242],A[241],A[240],A[239],A[238],A[237],A[236],A[235],A[234],A[233],A[232],A[231],A[230],A[229],A[228],A[227],A[226],A[225],A[224],A[223],A[222],A[221],A[220],A[219],A[218],A[217],A[216],A[215],A[214],A[213],A[212],A[211],A[210],A[209],A[208],A[207],A[206],A[205],A[204],A[203],A[202],A[201],A[200],A[199],A[198],A[197],A[196],A[195],A[194],A[193],A[192],A[191],A[190],A[189],A[188],A[187],A[186],A[185],A[184],A[183],A[182],A[181],A[180],A[179],A[178],A[177],A[176],A[175],A[174],A[173],A[172],A[171],A[170],A[169],A[168],A[167],A[166],A[165],A[164],A[163],A[162],A[161],A[160],A[159],A[158],A[157],A[156],A[155],A[154],A[153],A[152],A[151],A[150],A[149],A[148],A[147],A[146],A[145],A[144],A[143],A[142],A[141],A[140],A[139],A[138],A[137],A[136],A[135],A[134],A[133],A[132],A[131],A[130],A[129],A[128],A[127],A[126],A[125],A[124],A[123],A[122],A[121],A[120],A[119],A[118],A[117],A[116],A[115],A[114],A[113],A[112],A[111],A[110],A[109],A[108],A[107],A[106],A[105],A[104],A[103],A[102],A[101],A[100],A[99],A[98],A[97],A[96],A[95],A[94],A[93],A[92],A[91],A[90],A[89],A[88],A[87],A[86],A[85],A[84],A[83],A[82],A[81],A[80],A[79],A[78],A[77],A[76],A[75],A[74],A[73],A[72],A[71],A[70],A[69],A[68],A[67],A[66],A[65],A[64],A[63],A[62],A[61],A[60],A[59],A[58],A[57],A[56],A[55],A[54],A[53],A[52],A[51],A[50],A[49],A[48],A[47],A[46],A[45],A[44],A[43],A[42],A[41],A[40],A[39],A[38],A[37],A[36],A[35],A[34],A[33],A[32],A[31],A[30],A[29],A[28],A[27],A[26],A[25],A[24],A[23],A[22],A[21],A[20],A[19],A[18],A[17],A[16],A[15],A[14],A[13],A[12],A[11],A[10],A[9],A[8],A[7],A[6],A[5],A[4],A[3],A[2],A[1],A[0]
*.ipin
*+ B[255],B[254],B[253],B[252],B[251],B[250],B[249],B[248],B[247],B[246],B[245],B[244],B[243],B[242],B[241],B[240],B[239],B[238],B[237],B[236],B[235],B[234],B[233],B[232],B[231],B[230],B[229],B[228],B[227],B[226],B[225],B[224],B[223],B[222],B[221],B[220],B[219],B[218],B[217],B[216],B[215],B[214],B[213],B[212],B[211],B[210],B[209],B[208],B[207],B[206],B[205],B[204],B[203],B[202],B[201],B[200],B[199],B[198],B[197],B[196],B[195],B[194],B[193],B[192],B[191],B[190],B[189],B[188],B[187],B[186],B[185],B[184],B[183],B[182],B[181],B[180],B[179],B[178],B[177],B[176],B[175],B[174],B[173],B[172],B[171],B[170],B[169],B[168],B[167],B[166],B[165],B[164],B[163],B[162],B[161],B[160],B[159],B[158],B[157],B[156],B[155],B[154],B[153],B[152],B[151],B[150],B[149],B[148],B[147],B[146],B[145],B[144],B[143],B[142],B[141],B[140],B[139],B[138],B[137],B[136],B[135],B[134],B[133],B[132],B[131],B[130],B[129],B[128],B[127],B[126],B[125],B[124],B[123],B[122],B[121],B[120],B[119],B[118],B[117],B[116],B[115],B[114],B[113],B[112],B[111],B[110],B[109],B[108],B[107],B[106],B[105],B[104],B[103],B[102],B[101],B[100],B[99],B[98],B[97],B[96],B[95],B[94],B[93],B[92],B[91],B[90],B[89],B[88],B[87],B[86],B[85],B[84],B[83],B[82],B[81],B[80],B[79],B[78],B[77],B[76],B[75],B[74],B[73],B[72],B[71],B[70],B[69],B[68],B[67],B[66],B[65],B[64],B[63],B[62],B[61],B[60],B[59],B[58],B[57],B[56],B[55],B[54],B[53],B[52],B[51],B[50],B[49],B[48],B[47],B[46],B[45],B[44],B[43],B[42],B[41],B[40],B[39],B[38],B[37],B[36],B[35],B[34],B[33],B[32],B[31],B[30],B[29],B[28],B[27],B[26],B[25],B[24],B[23],B[22],B[21],B[20],B[19],B[18],B[17],B[16],B[15],B[14],B[13],B[12],B[11],B[10],B[9],B[8],B[7],B[6],B[5],B[4],B[3],B[2],B[1],B[0]
*.ipin CIN
*.opin
*+ S[255],S[254],S[253],S[252],S[251],S[250],S[249],S[248],S[247],S[246],S[245],S[244],S[243],S[242],S[241],S[240],S[239],S[238],S[237],S[236],S[235],S[234],S[233],S[232],S[231],S[230],S[229],S[228],S[227],S[226],S[225],S[224],S[223],S[222],S[221],S[220],S[219],S[218],S[217],S[216],S[215],S[214],S[213],S[212],S[211],S[210],S[209],S[208],S[207],S[206],S[205],S[204],S[203],S[202],S[201],S[200],S[199],S[198],S[197],S[196],S[195],S[194],S[193],S[192],S[191],S[190],S[189],S[188],S[187],S[186],S[185],S[184],S[183],S[182],S[181],S[180],S[179],S[178],S[177],S[176],S[175],S[174],S[173],S[172],S[171],S[170],S[169],S[168],S[167],S[166],S[165],S[164],S[163],S[162],S[161],S[160],S[159],S[158],S[157],S[156],S[155],S[154],S[153],S[152],S[151],S[150],S[149],S[148],S[147],S[146],S[145],S[144],S[143],S[142],S[141],S[140],S[139],S[138],S[137],S[136],S[135],S[134],S[133],S[132],S[131],S[130],S[129],S[128],S[127],S[126],S[125],S[124],S[123],S[122],S[121],S[120],S[119],S[118],S[117],S[116],S[115],S[114],S[113],S[112],S[111],S[110],S[109],S[108],S[107],S[106],S[105],S[104],S[103],S[102],S[101],S[100],S[99],S[98],S[97],S[96],S[95],S[94],S[93],S[92],S[91],S[90],S[89],S[88],S[87],S[86],S[85],S[84],S[83],S[82],S[81],S[80],S[79],S[78],S[77],S[76],S[75],S[74],S[73],S[72],S[71],S[70],S[69],S[68],S[67],S[66],S[65],S[64],S[63],S[62],S[61],S[60],S[59],S[58],S[57],S[56],S[55],S[54],S[53],S[52],S[51],S[50],S[49],S[48],S[47],S[46],S[45],S[44],S[43],S[42],S[41],S[40],S[39],S[38],S[37],S[36],S[35],S[34],S[33],S[32],S[31],S[30],S[29],S[28],S[27],S[26],S[25],S[24],S[23],S[22],S[21],S[20],S[19],S[18],S[17],S[16],S[15],S[14],S[13],S[12],S[11],S[10],S[9],S[8],S[7],S[6],S[5],S[4],S[3],S[2],S[1],S[0]
*.opin COUT
*.opin SP
*.opin SG
xadd64[3] A[255] A[254] A[253] A[252] A[251] A[250] A[249] A[248] A[247] A[246] A[245] A[244] A[243] A[242] A[241] A[240] A[239]
+ A[238] A[237] A[236] A[235] A[234] A[233] A[232] A[231] A[230] A[229] A[228] A[227] A[226] A[225] A[224] A[223] A[222] A[221] A[220]
+ A[219] A[218] A[217] A[216] A[215] A[214] A[213] A[212] A[211] A[210] A[209] A[208] A[207] A[206] A[205] A[204] A[203] A[202] A[201]
+ A[200] A[199] A[198] A[197] A[196] A[195] A[194] A[193] A[192] S[255] S[254] S[253] S[252] S[251] S[250] S[249] S[248] S[247] S[246]
+ S[245] S[244] S[243] S[242] S[241] S[240] S[239] S[238] S[237] S[236] S[235] S[234] S[233] S[232] S[231] S[230] S[229] S[228] S[227]
+ S[226] S[225] S[224] S[223] S[222] S[221] S[220] S[219] S[218] S[217] S[216] S[215] S[214] S[213] S[212] S[211] S[210] S[209] S[208]
+ S[207] S[206] S[205] S[204] S[203] S[202] S[201] S[200] S[199] S[198] S[197] S[196] S[195] S[194] S[193] S[192] B[255] B[254] B[253]
+ B[252] B[251] B[250] B[249] B[248] B[247] B[246] B[245] B[244] B[243] B[242] B[241] B[240] B[239] B[238] B[237] B[236] B[235] B[234]
+ B[233] B[232] B[231] B[230] B[229] B[228] B[227] B[226] B[225] B[224] B[223] B[222] B[221] B[220] B[219] B[218] B[217] B[216] B[215]
+ B[214] B[213] B[212] B[211] B[210] B[209] B[208] B[207] B[206] B[205] B[204] B[203] B[202] B[201] B[200] B[199] B[198] B[197] B[196]
+ B[195] B[194] B[193] B[192] net1 G[3] C3 P[3] adder_64bit
xadd64[2] A[191] A[190] A[189] A[188] A[187] A[186] A[185] A[184] A[183] A[182] A[181] A[180] A[179] A[178] A[177] A[176] A[175]
+ A[174] A[173] A[172] A[171] A[170] A[169] A[168] A[167] A[166] A[165] A[164] A[163] A[162] A[161] A[160] A[159] A[158] A[157] A[156]
+ A[155] A[154] A[153] A[152] A[151] A[150] A[149] A[148] A[147] A[146] A[145] A[144] A[143] A[142] A[141] A[140] A[139] A[138] A[137]
+ A[136] A[135] A[134] A[133] A[132] A[131] A[130] A[129] A[128] S[191] S[190] S[189] S[188] S[187] S[186] S[185] S[184] S[183] S[182]
+ S[181] S[180] S[179] S[178] S[177] S[176] S[175] S[174] S[173] S[172] S[171] S[170] S[169] S[168] S[167] S[166] S[165] S[164] S[163]
+ S[162] S[161] S[160] S[159] S[158] S[157] S[156] S[155] S[154] S[153] S[152] S[151] S[150] S[149] S[148] S[147] S[146] S[145] S[144]
+ S[143] S[142] S[141] S[140] S[139] S[138] S[137] S[136] S[135] S[134] S[133] S[132] S[131] S[130] S[129] S[128] B[191] B[190] B[189]
+ B[188] B[187] B[186] B[185] B[184] B[183] B[182] B[181] B[180] B[179] B[178] B[177] B[176] B[175] B[174] B[173] B[172] B[171] B[170]
+ B[169] B[168] B[167] B[166] B[165] B[164] B[163] B[162] B[161] B[160] B[159] B[158] B[157] B[156] B[155] B[154] B[153] B[152] B[151]
+ B[150] B[149] B[148] B[147] B[146] B[145] B[144] B[143] B[142] B[141] B[140] B[139] B[138] B[137] B[136] B[135] B[134] B[133] B[132]
+ B[131] B[130] B[129] B[128] net1 G[2] C2 P[2] adder_64bit
xadd64[1] A[127] A[126] A[125] A[124] A[123] A[122] A[121] A[120] A[119] A[118] A[117] A[116] A[115] A[114] A[113] A[112] A[111]
+ A[110] A[109] A[108] A[107] A[106] A[105] A[104] A[103] A[102] A[101] A[100] A[99] A[98] A[97] A[96] A[95] A[94] A[93] A[92] A[91] A[90]
+ A[89] A[88] A[87] A[86] A[85] A[84] A[83] A[82] A[81] A[80] A[79] A[78] A[77] A[76] A[75] A[74] A[73] A[72] A[71] A[70] A[69] A[68]
+ A[67] A[66] A[65] A[64] S[127] S[126] S[125] S[124] S[123] S[122] S[121] S[120] S[119] S[118] S[117] S[116] S[115] S[114] S[113] S[112]
+ S[111] S[110] S[109] S[108] S[107] S[106] S[105] S[104] S[103] S[102] S[101] S[100] S[99] S[98] S[97] S[96] S[95] S[94] S[93] S[92]
+ S[91] S[90] S[89] S[88] S[87] S[86] S[85] S[84] S[83] S[82] S[81] S[80] S[79] S[78] S[77] S[76] S[75] S[74] S[73] S[72] S[71] S[70]
+ S[69] S[68] S[67] S[66] S[65] S[64] B[127] B[126] B[125] B[124] B[123] B[122] B[121] B[120] B[119] B[118] B[117] B[116] B[115] B[114]
+ B[113] B[112] B[111] B[110] B[109] B[108] B[107] B[106] B[105] B[104] B[103] B[102] B[101] B[100] B[99] B[98] B[97] B[96] B[95] B[94]
+ B[93] B[92] B[91] B[90] B[89] B[88] B[87] B[86] B[85] B[84] B[83] B[82] B[81] B[80] B[79] B[78] B[77] B[76] B[75] B[74] B[73] B[72]
+ B[71] B[70] B[69] B[68] B[67] B[66] B[65] B[64] net1 G[1] C1 P[1] adder_64bit
xadd64[0] A[63] A[62] A[61] A[60] A[59] A[58] A[57] A[56] A[55] A[54] A[53] A[52] A[51] A[50] A[49] A[48] A[47] A[46] A[45] A[44]
+ A[43] A[42] A[41] A[40] A[39] A[38] A[37] A[36] A[35] A[34] A[33] A[32] A[31] A[30] A[29] A[28] A[27] A[26] A[25] A[24] A[23] A[22]
+ A[21] A[20] A[19] A[18] A[17] A[16] A[15] A[14] A[13] A[12] A[11] A[10] A[9] A[8] A[7] A[6] A[5] A[4] A[3] A[2] A[1] A[0] S[63] S[62]
+ S[61] S[60] S[59] S[58] S[57] S[56] S[55] S[54] S[53] S[52] S[51] S[50] S[49] S[48] S[47] S[46] S[45] S[44] S[43] S[42] S[41] S[40]
+ S[39] S[38] S[37] S[36] S[35] S[34] S[33] S[32] S[31] S[30] S[29] S[28] S[27] S[26] S[25] S[24] S[23] S[22] S[21] S[20] S[19] S[18]
+ S[17] S[16] S[15] S[14] S[13] S[12] S[11] S[10] S[9] S[8] S[7] S[6] S[5] S[4] S[3] S[2] S[1] S[0] B[63] B[62] B[61] B[60] B[59] B[58]
+ B[57] B[56] B[55] B[54] B[53] B[52] B[51] B[50] B[49] B[48] B[47] B[46] B[45] B[44] B[43] B[42] B[41] B[40] B[39] B[38] B[37] B[36]
+ B[35] B[34] B[33] B[32] B[31] B[30] B[29] B[28] B[27] B[26] B[25] B[24] B[23] B[22] B[21] B[20] B[19] B[18] B[17] B[16] B[15] B[14]
+ B[13] B[12] B[11] B[10] B[9] B[8] B[7] B[6] B[5] B[4] B[3] B[2] B[1] B[0] net1 G[0] CIN P[0] adder_64bit
xcla SG SP C1 P[3] P[2] P[1] P[0] C2 G[3] G[2] G[1] G[0] C3 COUT CIN cla_4bits
* noconn #net1
.ends

* expanding   symbol:  sky130_tests/adder_32bit.sym # of pins=7
** sym_path: /pdk/sky130A/libs.tech/xschem/sky130_tests/adder_32bit.sym
** sch_path: /pdk/sky130A/libs.tech/xschem/sky130_tests/adder_32bit.sch
.subckt adder_32bit A[31] A[30] A[29] A[28] A[27] A[26] A[25] A[24] A[23] A[22] A[21] A[20] A[19] A[18] A[17] A[16] A[15] A[14]
+ A[13] A[12] A[11] A[10] A[9] A[8] A[7] A[6] A[5] A[4] A[3] A[2] A[1] A[0] S[31] S[30] S[29] S[28] S[27] S[26] S[25] S[24] S[23] S[22]
+ S[21] S[20] S[19] S[18] S[17] S[16] S[15] S[14] S[13] S[12] S[11] S[10] S[9] S[8] S[7] S[6] S[5] S[4] S[3] S[2] S[1] S[0] B[31] B[30]
+ B[29] B[28] B[27] B[26] B[25] B[24] B[23] B[22] B[21] B[20] B[19] B[18] B[17] B[16] B[15] B[14] B[13] B[12] B[11] B[10] B[9] B[8] B[7]
+ B[6] B[5] B[4] B[3] B[2] B[1] B[0] COUT SG CIN SP
*.ipin
*+ A[31],A[30],A[29],A[28],A[27],A[26],A[25],A[24],A[23],A[22],A[21],A[20],A[19],A[18],A[17],A[16],A[15],A[14],A[13],A[12],A[11],A[10],A[9],A[8],A[7],A[6],A[5],A[4],A[3],A[2],A[1],A[0]
*.ipin
*+ B[31],B[30],B[29],B[28],B[27],B[26],B[25],B[24],B[23],B[22],B[21],B[20],B[19],B[18],B[17],B[16],B[15],B[14],B[13],B[12],B[11],B[10],B[9],B[8],B[7],B[6],B[5],B[4],B[3],B[2],B[1],B[0]
*.ipin CIN
*.opin
*+ S[31],S[30],S[29],S[28],S[27],S[26],S[25],S[24],S[23],S[22],S[21],S[20],S[19],S[18],S[17],S[16],S[15],S[14],S[13],S[12],S[11],S[10],S[9],S[8],S[7],S[6],S[5],S[4],S[3],S[2],S[1],S[0]
*.opin SP
*.opin SG
*.opin COUT
x0[1] A[31] A[30] A[29] A[28] A[27] A[26] A[25] A[24] A[23] A[22] A[21] A[20] A[19] A[18] A[17] A[16] S[31] S[30] S[29] S[28]
+ S[27] S[26] S[25] S[24] S[23] S[22] S[21] S[20] S[19] S[18] S[17] S[16] B[31] B[30] B[29] B[28] B[27] B[26] B[25] B[24] B[23] B[22]
+ B[21] B[20] B[19] B[18] B[17] B[16] net1 G[1] C1 P[1] adder_16bit
x0[0] A[15] A[14] A[13] A[12] A[11] A[10] A[9] A[8] A[7] A[6] A[5] A[4] A[3] A[2] A[1] A[0] S[15] S[14] S[13] S[12] S[11] S[10]
+ S[9] S[8] S[7] S[6] S[5] S[4] S[3] S[2] S[1] S[0] B[15] B[14] B[13] B[12] B[11] B[10] B[9] B[8] B[7] B[6] B[5] B[4] B[3] B[2] B[1]
+ B[0] net1 G[0] CIN P[0] adder_16bit
xcla SG SP C1 P[1] P[0] COUT G[1] G[0] CIN cla_2bits
* noconn #net1
.ends

* expanding   symbol:  sky130_tests/zero_opamp.sym # of pins=7
** sym_path: /pdk/sky130A/libs.tech/xschem/sky130_tests/zero_opamp.sym
** sch_path: /pdk/sky130A/libs.tech/xschem/sky130_tests/zero_opamp.sch
.subckt zero_opamp EN_N MINUS PLUS DIFFOUT VCC VSS ADJ
*.ipin PLUS
*.ipin MINUS
*.ipin EN_N
*.ipin VSS
*.ipin VCC
*.opin DIFFOUT
*.ipin ADJ
C6 G1 0 2f
XM4 net9 EN_N VCC VCC sky130_fd_pr__pfet_01v8 L=8 W=2 nf=1 ad=0.58 as=0.58 pd=4.58 ps=4.58 nrd=0.145 nrs=0.145 sa=0 sb=0 sd=0
+ mult=1
XM18 G2 G2 net7 VSS sky130_fd_pr__nfet_01v8_lvt L=4 W=2 nf=1 ad=0.58 as=0.58 pd=4.58 ps=4.58 nrd=0.145 nrs=0.145 sa=0 sb=0 sd=0
+ mult=1
XM2 G1 G1 net8 VSS sky130_fd_pr__nfet_01v8_lvt L=4 W=2 nf=1 ad=0.58 as=0.58 pd=4.58 ps=4.58 nrd=0.145 nrs=0.145 sa=0 sb=0 sd=0
+ mult=1
XMR G2 PLUS net10 VCC sky130_fd_pr__pfet_01v8_lvt L=2 W=8 nf=1 ad=2.32 as=2.32 pd=16.58 ps=16.58 nrd=0.03625 nrs=0.03625 sa=0 sb=0
+ sd=0 mult=1
XML G1 MINUS net11 VCC sky130_fd_pr__pfet_01v8_lvt L=2 W=8 nf=1 ad=2.32 as=2.32 pd=16.58 ps=16.58 nrd=0.03625 nrs=0.03625 sa=0
+ sb=0 sd=0 mult=1
v1 SP net11 0
.save i(v1)
C4 SP 0 2f
C1 G2 0 2f
C5 DIFFOUT 0 4f
XM6 DIFFOUT G2 net1 VSS sky130_fd_pr__nfet_01v8_lvt L=4 W=2 nf=1 ad=0.58 as=0.58 pd=4.58 ps=4.58 nrd=0.145 nrs=0.145 sa=0 sb=0
+ sd=0 mult=1
v2 SP net10 0
.save i(v2)
v4 net1 VSS 0
.save i(v4)
v6 net9 SP 0
.save i(v6)
XM7 DIFFOUT EN_N VSS VSS sky130_fd_pr__nfet_01v8 L=0.15 W=0.5 nf=1 ad=0.145 as=0.145 pd=1.58 ps=1.58 nrd=0.58 nrs=0.58 sa=0 sb=0
+ sd=0 mult=1
XM46 net12 EN_N VCC VCC sky130_fd_pr__pfet_01v8 L=0.15 W=5 nf=1 ad=1.45 as=1.45 pd=10.58 ps=10.58 nrd=0.058 nrs=0.058 sa=0 sb=0
+ sd=0 mult=1
v17 net12 net3 0
.save i(v17)
XM12 net2 G1 VSS VSS sky130_fd_pr__nfet_01v8_lvt L=4 W=2 nf=1 ad=0.58 as=0.58 pd=4.58 ps=4.58 nrd=0.145 nrs=0.145 sa=0 sb=0 sd=0
+ mult=1
XM54 net2 net2 net3 VCC sky130_fd_pr__pfet_01v8_lvt L=4 W=4 nf=1 ad=1.16 as=1.16 pd=8.58 ps=8.58 nrd=0.0725 nrs=0.0725 sa=0 sb=0
+ sd=0 mult=1
XM5 DIFFOUT net2 net3 VCC sky130_fd_pr__pfet_01v8_lvt L=4 W=4 nf=1 ad=1.16 as=1.16 pd=8.58 ps=8.58 nrd=0.0725 nrs=0.0725 sa=0 sb=0
+ sd=0 mult=1
XM8 net5 ADJ net4 VCC sky130_fd_pr__pfet_01v8_lvt L=1 W=1 nf=1 ad=0.29 as=0.29 pd=2.58 ps=2.58 nrd=0.29 nrs=0.29 sa=0 sb=0 sd=0
+ mult=1
XM9 net5 ADJ net6 VSS sky130_fd_pr__nfet_01v8 L=1 W=0.5 nf=1 ad=0.145 as=0.145 pd=1.58 ps=1.58 nrd=0.58 nrs=0.58 sa=0 sb=0 sd=0
+ mult=1
XM10 net6 VCC VSS VSS sky130_fd_pr__nfet_01v8 L=8 W=0.5 nf=1 ad=0.145 as=0.145 pd=1.58 ps=1.58 nrd=0.58 nrs=0.58 sa=0 sb=0 sd=0
+ mult=1
XM1 net4 EN_N VCC VCC sky130_fd_pr__pfet_01v8 L=8 W=1 nf=1 ad=0.29 as=0.29 pd=2.58 ps=2.58 nrd=0.29 nrs=0.29 sa=0 sb=0 sd=0 mult=1
v3 net5 G1 0
.save i(v3)
v5 net7 VSS 0
.save i(v5)
v7 net8 VSS 0
.save i(v7)
.ends

* expanding   symbol:  sky130_tests/gain_stage.sym # of pins=7
** sym_path: /pdk/sky130A/libs.tech/xschem/sky130_tests/gain_stage.sym
** sch_path: /pdk/sky130A/libs.tech/xschem/sky130_tests/gain_stage.sch
.subckt gain_stage IN OUT VCC VSS START_N START EN_N  wcap=10 WN=0.5 WP=1
*.ipin IN
*.ipin VSS
*.ipin VCC
*.opin OUT
*.ipin START
*.ipin START_N
*.ipin EN_N
C5 OUT 0 4f
XM6 OUT IN net1 VSS sky130_fd_pr__nfet_01v8_lvt L=1 W=WN nf=1 ad='int((1 + 1)/2) * WN / 1 * 0.29' as='int((1 + 2)/2) * WN / 1 * 0.29'
+ pd='2*int((1 + 1)/2) * (WN / 1 + 0.29)' ps='2*int((1 + 2)/2) * (WN / 1 + 0.29)' nrd='0.29 / WN ' nrs='0.29 / WN ' sa=0 sb=0 sd=0 mult=1
v4 net1 VSS 0
.save i(v4)
XM7 OUT EN_N VSS VSS sky130_fd_pr__nfet_01v8 L=0.15 W=0.5 nf=1 ad=0.145 as=0.145 pd=1.58 ps=1.58 nrd=0.58 nrs=0.58 sa=0 sb=0 sd=0
+ mult=3 m=3
XM46 net6 EN_N VCC VCC sky130_fd_pr__pfet_01v8 L=0.15 W=5 nf=1 ad=1.45 as=1.45 pd=10.58 ps=10.58 nrd=0.058 nrs=0.058 sa=0 sb=0
+ sd=0 mult=1
v17 net6 net2 0
.save i(v17)
XM5 OUT IN net2 VCC sky130_fd_pr__pfet_01v8_lvt L=1 W=WP nf=1 ad='int((1 + 1)/2) * WP / 1 * 0.29' as='int((1 + 2)/2) * WP / 1 * 0.29'
+ pd='2*int((1 + 1)/2) * (WP / 1 + 0.29)' ps='2*int((1 + 2)/2) * (WP / 1 + 0.29)' nrd='0.29 / WP ' nrs='0.29 / WP ' sa=0 sb=0 sd=0 mult=1
XM8 net4 ADJ net3 VCC sky130_fd_pr__pfet_01v8_lvt L=1 W=WP nf=1 ad='int((1 + 1)/2) * WP / 1 * 0.29' as='int((1 + 2)/2) * WP / 1 * 0.29'
+ pd='2*int((1 + 1)/2) * (WP / 1 + 0.29)' ps='2*int((1 + 2)/2) * (WP / 1 + 0.29)' nrd='0.29 / WP ' nrs='0.29 / WP ' sa=0 sb=0 sd=0 mult=1
XM9 net4 ADJ net5 VSS sky130_fd_pr__nfet_01v8_lvt L=1 W=WN nf=1 ad='int((1 + 1)/2) * WN / 1 * 0.29' as='int((1 + 2)/2) * WN / 1 * 0.29'
+ pd='2*int((1 + 1)/2) * (WN / 1 + 0.29)' ps='2*int((1 + 2)/2) * (WN / 1 + 0.29)' nrd='0.29 / WN ' nrs='0.29 / WN ' sa=0 sb=0 sd=0 mult=1
XM10 net5 VCC VSS VSS sky130_fd_pr__nfet_01v8 L=4 W=WN nf=1 ad='int((1 + 1)/2) * WN / 1 * 0.29' as='int((1 + 2)/2) * WN / 1 * 0.29'
+ pd='2*int((1 + 1)/2) * (WN / 1 + 0.29)' ps='2*int((1 + 2)/2) * (WN / 1 + 0.29)' nrd='0.29 / WN ' nrs='0.29 / WN ' sa=0 sb=0 sd=0 mult=1
XM1 net3 EN_N VCC VCC sky130_fd_pr__pfet_01v8 L=4 W=WP nf=1 ad='int((1 + 1)/2) * WP / 1 * 0.29' as='int((1 + 2)/2) * WP / 1 * 0.29'
+ pd='2*int((1 + 1)/2) * (WP / 1 + 0.29)' ps='2*int((1 + 2)/2) * (WP / 1 + 0.29)' nrd='0.29 / WP ' nrs='0.29 / WP ' sa=0 sb=0 sd=0 mult=1
C1 IN 0 4f
x6 ADJ OUT START START_N VCC VSS passgate_1 W_N=0.42 L_N=0.35 W_P=0.6 L_P=0.35
XC2 ADJ VSS sky130_fd_pr__cap_mim_m3_2 W=wcap L=wcap MF=2 m=2
v1 net4 OUT 0
.save i(v1)
.ends

* expanding   symbol:  passgate_1.sym # of pins=4
** sym_path: /pdk/sky130A/libs.tech/xschem/sky130_tests/passgate.sym
** sch_path: /pdk/sky130A/libs.tech/xschem/sky130_tests/passgate.sch
.subckt passgate_1 Z A GP GN VCCBPIN VSSBPIN  W_N=1 L_N=0.2 W_P=1 L_P=0.2

*.iopin A
*.iopin Z
*.ipin GP
*.ipin GN
XM1 Z GN A VSSBPIN sky130_fd_pr__nfet_01v8 L=L_N W=W_N nf=1 ad='int((1 + 1)/2) * W_N / 1 * 0.29' as='int((1 + 2)/2) * W_N / 1 * 0.29'
+ pd='2*int((1 + 1)/2) * (W_N / 1 + 0.29)' ps='2*int((1 + 2)/2) * (W_N / 1 + 0.29)' nrd='0.29 / W_N ' nrs='0.29 / W_N ' sa=0 sb=0 sd=0
+ mult=1
XM2 Z GP A VCCBPIN sky130_fd_pr__pfet_01v8_lvt L=L_P W=W_P nf=1 ad='int((1 + 1)/2) * W_P / 1 * 0.29' as='int((1 + 2)/2) * W_P / 1 * 0.29'
+ pd='2*int((1 + 1)/2) * (W_P / 1 + 0.29)' ps='2*int((1 + 2)/2) * (W_P / 1 + 0.29)' nrd='0.29 / W_P ' nrs='0.29 / W_P ' sa=0 sb=0 sd=0
+ mult=1
* noconn VCCBPIN
* noconn VSSBPIN
.ends

* expanding   symbol:  gain_stage2.sym # of pins=7
** sym_path: /pdk/sky130A/libs.tech/xschem/sky130_tests/gain_stage.sym
** sch_path: /pdk/sky130A/libs.tech/xschem/sky130_tests/gain_stage.sch
.subckt gain_stage2 IN OUT VCC VSS START_N START EN_N  wcap=10 WN=0.5 WP=1
*.ipin IN
*.ipin VSS
*.ipin VCC
*.opin OUT
*.ipin START
*.ipin START_N
*.ipin EN_N
C5 OUT 0 4f
XM6 OUT IN net1 VSS sky130_fd_pr__nfet_01v8 L=1 W=WN nf=1 ad='int((1 + 1)/2) * WN / 1 * 0.29' as='int((1 + 2)/2) * WN / 1 * 0.29' pd='2*int((1 + 1)/2) * (WN / 1 + 0.29)'
+ ps='2*int((1 + 2)/2) * (WN / 1 + 0.29)' nrd='0.29 / WN ' nrs='0.29 / WN ' sa=0 sb=0 sd=0 mult=1
v4 net1 VSS 0
.save i(v4)
XM7 OUT EN_N VSS VSS sky130_fd_pr__nfet_01v8 L=0.15 W=0.5 nf=1 ad=0.145 as=0.145 pd=1.58 ps=1.58 nrd=0.58 nrs=0.58 sa=0 sb=0 sd=0
+ mult=3 m=3
XM46 net6 EN_N VCC VCC sky130_fd_pr__pfet_01v8 L=0.15 W=5 nf=1 ad=1.45 as=1.45 pd=10.58 ps=10.58 nrd=0.058 nrs=0.058 sa=0 sb=0
+ sd=0 mult=1
v17 net6 net2 0
.save i(v17)
XM5 OUT IN net2 VCC sky130_fd_pr__pfet_01v8_lvt L=1 W=WP nf=1 ad='int((1 + 1)/2) * WP / 1 * 0.29' as='int((1 + 2)/2) * WP / 1 * 0.29'
+ pd='2*int((1 + 1)/2) * (WP / 1 + 0.29)' ps='2*int((1 + 2)/2) * (WP / 1 + 0.29)' nrd='0.29 / WP ' nrs='0.29 / WP ' sa=0 sb=0 sd=0 mult=1
XM8 net4 ADJ net3 VCC sky130_fd_pr__pfet_01v8_lvt L=1 W=WP nf=1 ad='int((1 + 1)/2) * WP / 1 * 0.29' as='int((1 + 2)/2) * WP / 1 * 0.29'
+ pd='2*int((1 + 1)/2) * (WP / 1 + 0.29)' ps='2*int((1 + 2)/2) * (WP / 1 + 0.29)' nrd='0.29 / WP ' nrs='0.29 / WP ' sa=0 sb=0 sd=0 mult=1
XM9 net4 ADJ net5 VSS sky130_fd_pr__nfet_01v8 L=1 W=WN nf=1 ad='int((1 + 1)/2) * WN / 1 * 0.29' as='int((1 + 2)/2) * WN / 1 * 0.29'
+ pd='2*int((1 + 1)/2) * (WN / 1 + 0.29)' ps='2*int((1 + 2)/2) * (WN / 1 + 0.29)' nrd='0.29 / WN ' nrs='0.29 / WN ' sa=0 sb=0 sd=0 mult=1
XM10 net5 VCC VSS VSS sky130_fd_pr__nfet_01v8 L=4 W=WN nf=1 ad='int((1 + 1)/2) * WN / 1 * 0.29' as='int((1 + 2)/2) * WN / 1 * 0.29'
+ pd='2*int((1 + 1)/2) * (WN / 1 + 0.29)' ps='2*int((1 + 2)/2) * (WN / 1 + 0.29)' nrd='0.29 / WN ' nrs='0.29 / WN ' sa=0 sb=0 sd=0 mult=1
XM1 net3 EN_N VCC VCC sky130_fd_pr__pfet_01v8 L=4 W=WP nf=1 ad='int((1 + 1)/2) * WP / 1 * 0.29' as='int((1 + 2)/2) * WP / 1 * 0.29'
+ pd='2*int((1 + 1)/2) * (WP / 1 + 0.29)' ps='2*int((1 + 2)/2) * (WP / 1 + 0.29)' nrd='0.29 / WP ' nrs='0.29 / WP ' sa=0 sb=0 sd=0 mult=1
C1 IN 0 4f
x6 ADJ OUT START START_N VCC VSS passgate_1 W_N=0.42 L_N=0.35 W_P=0.6 L_P=0.35
XC2 ADJ VSS sky130_fd_pr__cap_mim_m3_2 W=wcap L=wcap MF=2 m=2
v1 net4 OUT 0
.save i(v1)
.ends

* expanding   symbol:  sky130_tests/charge_pump.sym # of pins=6
** sym_path: /pdk/sky130A/libs.tech/xschem/sky130_tests/charge_pump.sym
** sch_path: /pdk/sky130A/libs.tech/xschem/sky130_tests/charge_pump.sch
.subckt charge_pump VCC HV A B C D
*.ipin A
*.ipin B
*.ipin C
*.ipin D
*.ipin VCC
*.iopin HV
XM1 net15 net9 net16 net5 sky130_fd_pr__nfet_g5v0d10v5 L=0.5 W=8 nf=1 ad=2.32 as=2.32 pd=16.58 ps=16.58 nrd=0.03625 nrs=0.03625
+ sa=0 sb=0 sd=0 mult=1
XM2 VCC HV1A G1A VCC sky130_fd_pr__nfet_g5v0d10v5 L=0.5 W=1.5 nf=1 ad=0.435 as=0.435 pd=3.58 ps=3.58 nrd=0.193333333333333
+ nrs=0.193333333333333 sa=0 sb=0 sd=0 mult=1
XM3 net1 net10 net17 net6 sky130_fd_pr__nfet_g5v0d10v5 L=0.5 W=8 nf=1 ad=2.32 as=2.32 pd=16.58 ps=16.58 nrd=0.03625 nrs=0.03625
+ sa=0 sb=0 sd=0 mult=1
XM4 HV1A HV2A G2A HV1A sky130_fd_pr__nfet_g5v0d10v5 L=0.5 W=1.5 nf=1 ad=0.435 as=0.435 pd=3.58 ps=3.58 nrd=0.193333333333333
+ nrs=0.193333333333333 sa=0 sb=0 sd=0 mult=1
XM5 HV2A net11 HV3A HV2A sky130_fd_pr__nfet_g5v0d10v5 L=0.5 W=1.5 nf=1 ad=0.435 as=0.435 pd=3.58 ps=3.58 nrd=0.193333333333333
+ nrs=0.193333333333333 sa=0 sb=0 sd=0 mult=1
XM6 HV2A HV3A G3A HV2A sky130_fd_pr__nfet_g5v0d10v5 L=0.5 W=1.5 nf=1 ad=0.435 as=0.435 pd=3.58 ps=3.58 nrd=0.193333333333333
+ nrs=0.193333333333333 sa=0 sb=0 sd=0 mult=1
XM7 HV2A G3A net3 HV2A sky130_fd_pr__nfet_g5v0d10v5 L=0.5 W=8 nf=1 ad=2.32 as=2.32 pd=16.58 ps=16.58 nrd=0.03625 nrs=0.03625 sa=0
+ sb=0 sd=0 mult=1
XC1 G1A A sky130_fd_pr__cap_mim_m3_1 W=6 L=4 MF=1
XC2 HV1A B sky130_fd_pr__cap_mim_m3_1 W=30 L=15 MF=1
XC3 G2A C sky130_fd_pr__cap_mim_m3_1 W=6 L=4 MF=1
XC4 HV2A D sky130_fd_pr__cap_mim_m3_1 W=30 L=15 MF=1
XC5 G3A A sky130_fd_pr__cap_mim_m3_1 W=6 L=4 MF=1
XC6 HV3A B sky130_fd_pr__cap_mim_m3_1 W=6 L=4 MF=1
XM8 net18 net12 net19 net7 sky130_fd_pr__nfet_g5v0d10v5 L=0.5 W=8 nf=1 ad=2.32 as=2.32 pd=16.58 ps=16.58 nrd=0.03625 nrs=0.03625
+ sa=0 sb=0 sd=0 mult=1
XM9 VCC HV1B G1B VCC sky130_fd_pr__nfet_g5v0d10v5 L=0.5 W=1.5 nf=1 ad=0.435 as=0.435 pd=3.58 ps=3.58 nrd=0.193333333333333
+ nrs=0.193333333333333 sa=0 sb=0 sd=0 mult=1
XM10 net2 net13 net20 net8 sky130_fd_pr__nfet_g5v0d10v5 L=0.5 W=8 nf=1 ad=2.32 as=2.32 pd=16.58 ps=16.58 nrd=0.03625 nrs=0.03625
+ sa=0 sb=0 sd=0 mult=1
XM11 HV1B HV2B G2B HV1B sky130_fd_pr__nfet_g5v0d10v5 L=0.5 W=1.5 nf=1 ad=0.435 as=0.435 pd=3.58 ps=3.58 nrd=0.193333333333333
+ nrs=0.193333333333333 sa=0 sb=0 sd=0 mult=1
XM12 HV2B net14 HV3B HV2B sky130_fd_pr__nfet_g5v0d10v5 L=0.5 W=1.5 nf=1 ad=0.435 as=0.435 pd=3.58 ps=3.58 nrd=0.193333333333333
+ nrs=0.193333333333333 sa=0 sb=0 sd=0 mult=1
XM13 HV2B HV3B G3B HV2B sky130_fd_pr__nfet_g5v0d10v5 L=0.5 W=1.5 nf=1 ad=0.435 as=0.435 pd=3.58 ps=3.58 nrd=0.193333333333333
+ nrs=0.193333333333333 sa=0 sb=0 sd=0 mult=1
XM14 HV2B G3B net4 HV2B sky130_fd_pr__nfet_g5v0d10v5 L=0.5 W=8 nf=1 ad=2.32 as=2.32 pd=16.58 ps=16.58 nrd=0.03625 nrs=0.03625 sa=0
+ sb=0 sd=0 mult=1
XC7 G1B C sky130_fd_pr__cap_mim_m3_1 W=6 L=4 MF=1
XC8 HV1B D sky130_fd_pr__cap_mim_m3_1 W=30 L=15 MF=1
XC9 G2B A sky130_fd_pr__cap_mim_m3_1 W=6 L=4 MF=1
XC10 HV2B B sky130_fd_pr__cap_mim_m3_1 W=30 L=15 MF=1
XC11 G3B C sky130_fd_pr__cap_mim_m3_1 W=6 L=4 MF=1
XC12 HV3B D sky130_fd_pr__cap_mim_m3_1 W=6 L=4 MF=1
V1 HV1B net2 0
.save i(v1)
V2 net3 HV 0
.save i(v2)
V3 net4 HV 0
.save i(v3)
V4 HV1A net1 0
.save i(v4)
V5 VCC net18 0
.save i(v5)
V6 VCC net15 0
.save i(v6)
V7 net20 HV2B 0
.save i(v7)
V8 net17 HV2A 0
.save i(v8)
V9 VCC net5 0
.save i(v9)
V10 HV1A net6 0
.save i(v10)
V11 VCC net7 0
.save i(v11)
V12 HV1B net8 0
.save i(v12)
V13 net19 HV1B 0
.save i(v13)
V14 net16 HV1A 0
.save i(v14)
V15 G1A net9 0
.save i(v15)
V16 G2A net10 0
.save i(v16)
V17 G3A net11 0
.save i(v17)
V18 G1B net12 0
.save i(v18)
V19 G2B net13 0
.save i(v19)
V20 G3B net14 0
.save i(v20)
.ends

* expanding   symbol:  sky130_tests/charge_pump_phasegen.sym # of pins=6
** sym_path: /pdk/sky130A/libs.tech/xschem/sky130_tests/charge_pump_phasegen.sym
** sch_path: /pdk/sky130A/libs.tech/xschem/sky130_tests/charge_pump_phasegen.sch
.subckt charge_pump_phasegen A B C CK D VCC
*.ipin CK
*.opin A
*.opin B
*.opin C
*.opin D
*.ipin VCC
x1 CKN BN GND GND VCC VCC AN sky130_fd_sc_hd__nand2_2
x2 AN GND GND VCC VCC A sky130_fd_sc_hd__inv_4
x5 AN CK GND GND VCC VCC net1 sky130_fd_sc_hd__nand2_1
x6 net1 net2 GND GND VCC VCC net5 sky130_fd_sc_hd__nand2_1
x7 DI net6 VCC GND lvtnot W_N=0.5 L_N=1 W_P=1 L_P=1
x8 net6 net2 VCC GND lvtnot W_N=0.5 L_N=1 W_P=1 L_P=1
x9 BN GND GND VCC VCC B sky130_fd_sc_hd__inv_12
x10 net5 GND GND VCC VCC BN sky130_fd_sc_hd__inv_2
x11 CK DN GND GND VCC VCC CN sky130_fd_sc_hd__nand2_2
x12 CN GND GND VCC VCC C sky130_fd_sc_hd__inv_4
x13 CN CKN GND GND VCC VCC net3 sky130_fd_sc_hd__nand2_1
x14 net3 net4 GND GND VCC VCC net7 sky130_fd_sc_hd__nand2_1
x15 BI net8 VCC GND lvtnot W_N=0.5 L_N=1 W_P=1 L_P=1
x16 net8 net4 VCC GND lvtnot W_N=0.5 L_N=1 W_P=1 L_P=1
x17 DN GND GND VCC VCC D sky130_fd_sc_hd__inv_12
x18 net7 GND GND VCC VCC DN sky130_fd_sc_hd__inv_2
x3 CK GND GND VCC VCC CKN sky130_fd_sc_hd__inv_12
* noconn VCC
x19 BN GND GND VCC VCC BI sky130_fd_sc_hd__inv_2
x20 DN GND GND VCC VCC DI sky130_fd_sc_hd__inv_2
.ends

* expanding   symbol:  sky130_tests/charge_pump2.sym # of pins=4
** sym_path: /pdk/sky130A/libs.tech/xschem/sky130_tests/charge_pump2.sym
** sch_path: /pdk/sky130A/libs.tech/xschem/sky130_tests/charge_pump2.sch
.subckt charge_pump2 VCC HV CK CKN
*.ipin VCC
*.iopin HV
*.ipin CK
*.ipin CKN
XM8 D1 GN1 VCC VCC sky130_fd_pr__nfet_g5v0d10v5 L=0.5 W=8 nf=1 ad=2.32 as=2.32 pd=16.58 ps=16.58 nrd=0.03625 nrs=0.03625 sa=0 sb=0
+ sd=0 mult=1
XM9 D2 GN2 VCC VCC sky130_fd_pr__nfet_g5v0d10v5 L=0.5 W=8 nf=1 ad=2.32 as=2.32 pd=16.58 ps=16.58 nrd=0.03625 nrs=0.03625 sa=0 sb=0
+ sd=0 mult=1
XM10 D1 GP1 HV1 HV1 sky130_fd_pr__pfet_g5v0d10v5 L=0.5 W=16 nf=1 ad=4.64 as=4.64 pd=32.58 ps=32.58 nrd=0.018125 nrs=0.018125 sa=0
+ sb=0 sd=0 mult=1
XM11 D2 GP2 HV1 HV1 sky130_fd_pr__pfet_g5v0d10v5 L=0.5 W=16 nf=1 ad=4.64 as=4.64 pd=32.58 ps=32.58 nrd=0.018125 nrs=0.018125 sa=0
+ sb=0 sd=0 mult=1
XC7 D2 net1 sky130_fd_pr__cap_mim_m3_1 W=30 L=15 MF=1
XC8 D1 net2 sky130_fd_pr__cap_mim_m3_1 W=30 L=15 MF=1
XM12 D3 GN3 HV1 HV1 sky130_fd_pr__nfet_g5v0d10v5 L=0.5 W=8 nf=1 ad=2.32 as=2.32 pd=16.58 ps=16.58 nrd=0.03625 nrs=0.03625 sa=0
+ sb=0 sd=0 mult=1
XM13 D4 GN4 HV1 HV1 sky130_fd_pr__nfet_g5v0d10v5 L=0.5 W=8 nf=1 ad=2.32 as=2.32 pd=16.58 ps=16.58 nrd=0.03625 nrs=0.03625 sa=0
+ sb=0 sd=0 mult=1
XM14 D3 GP3 HV HV sky130_fd_pr__pfet_g5v0d10v5 L=0.5 W=16 nf=1 ad=4.64 as=4.64 pd=32.58 ps=32.58 nrd=0.018125 nrs=0.018125 sa=0
+ sb=0 sd=0 mult=1
XM15 D4 GP4 HV HV sky130_fd_pr__pfet_g5v0d10v5 L=0.5 W=16 nf=1 ad=4.64 as=4.64 pd=32.58 ps=32.58 nrd=0.018125 nrs=0.018125 sa=0
+ sb=0 sd=0 mult=1
XC9 D4 net3 sky130_fd_pr__cap_mim_m3_1 W=30 L=15 MF=1
XC10 D3 net4 sky130_fd_pr__cap_mim_m3_1 W=30 L=15 MF=1
x12 CK GND GND VCC VCC net1 sky130_fd_sc_hd__inv_6
x1 CKN GND GND VCC VCC net2 sky130_fd_sc_hd__inv_6
x2 CK GND GND VCC VCC net3 sky130_fd_sc_hd__inv_6
x3 CKN GND GND VCC VCC net4 sky130_fd_sc_hd__inv_6
XM1 GP3 GP4 HV HV sky130_fd_pr__pfet_g5v0d10v5 L=0.5 W=1 nf=1 ad=0.29 as=0.29 pd=2.58 ps=2.58 nrd=0.29 nrs=0.29 sa=0 sb=0 sd=0
+ mult=1
XM2 GP4 GP3 HV HV sky130_fd_pr__pfet_g5v0d10v5 L=0.5 W=1 nf=1 ad=0.29 as=0.29 pd=2.58 ps=2.58 nrd=0.29 nrs=0.29 sa=0 sb=0 sd=0
+ mult=1
XC1 GP3 net5 sky130_fd_pr__cap_mim_m3_1 W=6 L=8 MF=1
XC2 GP4 net6 sky130_fd_pr__cap_mim_m3_1 W=6 L=8 MF=1
XM3 GP1 GP2 HV1 HV1 sky130_fd_pr__pfet_g5v0d10v5 L=0.5 W=1 nf=1 ad=0.29 as=0.29 pd=2.58 ps=2.58 nrd=0.29 nrs=0.29 sa=0 sb=0 sd=0
+ mult=1
XM4 GP2 GP1 HV1 HV1 sky130_fd_pr__pfet_g5v0d10v5 L=0.5 W=1 nf=1 ad=0.29 as=0.29 pd=2.58 ps=2.58 nrd=0.29 nrs=0.29 sa=0 sb=0 sd=0
+ mult=1
XC3 GP1 net7 sky130_fd_pr__cap_mim_m3_1 W=6 L=8 MF=1
XC4 GP2 net8 sky130_fd_pr__cap_mim_m3_1 W=6 L=8 MF=1
x4 CK GND GND VCC VCC net5 sky130_fd_sc_hd__inv_2
x5 CKN GND GND VCC VCC net6 sky130_fd_sc_hd__inv_2
x6 CK GND GND VCC VCC net7 sky130_fd_sc_hd__inv_2
x7 CKN GND GND VCC VCC net8 sky130_fd_sc_hd__inv_2
XC5 GN1 net9 sky130_fd_pr__cap_mim_m3_1 W=6 L=4 MF=1
XC6 GN2 net10 sky130_fd_pr__cap_mim_m3_1 W=6 L=4 MF=1
x8 CK GND GND VCC VCC net9 sky130_fd_sc_hd__inv_2
x9 CKN GND GND VCC VCC net10 sky130_fd_sc_hd__inv_2
XM5 VCC GN1 GN2 VCC sky130_fd_pr__nfet_g5v0d10v5 L=0.5 W=0.5 nf=1 ad=0.145 as=0.145 pd=1.58 ps=1.58 nrd=0.58 nrs=0.58 sa=0 sb=0
+ sd=0 mult=1
XM6 VCC GN2 GN1 VCC sky130_fd_pr__nfet_g5v0d10v5 L=0.5 W=0.5 nf=1 ad=0.145 as=0.145 pd=1.58 ps=1.58 nrd=0.58 nrs=0.58 sa=0 sb=0
+ sd=0 mult=1
XC11 GN3 net11 sky130_fd_pr__cap_mim_m3_1 W=6 L=4 MF=1
XC12 GN4 net12 sky130_fd_pr__cap_mim_m3_1 W=6 L=4 MF=1
x10 CK GND GND VCC VCC net11 sky130_fd_sc_hd__inv_2
x11 CKN GND GND VCC VCC net12 sky130_fd_sc_hd__inv_2
XM7 HV1 GN3 GN4 HV1 sky130_fd_pr__nfet_g5v0d10v5 L=0.5 W=0.5 nf=1 ad=0.145 as=0.145 pd=1.58 ps=1.58 nrd=0.58 nrs=0.58 sa=0 sb=0
+ sd=0 mult=1
XM16 HV1 GN4 GN3 HV1 sky130_fd_pr__nfet_g5v0d10v5 L=0.5 W=0.5 nf=1 ad=0.145 as=0.145 pd=1.58 ps=1.58 nrd=0.58 nrs=0.58 sa=0 sb=0
+ sd=0 mult=1
.ends

* expanding   symbol:  sky130_tests/charge_pump_ideal.sym # of pins=4
** sym_path: /pdk/sky130A/libs.tech/xschem/sky130_tests/charge_pump_ideal.sym
** sch_path: /pdk/sky130A/libs.tech/xschem/sky130_tests/charge_pump_ideal.sch
.subckt charge_pump_ideal VCC HV CK CKN
*.iopin HV
*.ipin VCC
*.ipin CK
*.ipin CKN
X4 net2 HV diode_ngspice Ron=0.1 Roff=1e9
X5 net1 net2 diode_ngspice Ron=0.1 Roff=1e9
X6 VCC net1 diode_ngspice Ron=0.1 Roff=1e9
C1 net2 CKNI 1.82p
C2 net1 CKI 1.82p
S1 CKNI GND CK GND SW1
S2 VCC CKNI VCC CK SW1
S3 CKI GND CKN GND SW1
S4 VCC CKI VCC CKN SW1
C3 CKI 0 50f
C4 CKNI 0 50f
.ends

* expanding   symbol:  sky130_tests/ota1tb.sym # of pins=5
** sym_path: /pdk/sky130A/libs.tech/xschem/sky130_tests/ota1tb.sym
** sch_path: /pdk/sky130A/libs.tech/xschem/sky130_tests/ota1tb.sch
.subckt ota1tb VDD minus plus out gnd
*.ipin minus
*.ipin plus
*.ipin VDD
*.ipin gnd
*.opin out
XM6 net3 net3 gnd GND sky130_fd_pr__nfet_01v8 L=1.5 W=0.564 nf=1 ad=0.16356 as=0.16356 pd=1.708 ps=1.708 nrd=0.514184397163121
+ nrs=0.514184397163121 sa=0 sb=0 sd=0 mult=1
XM8 out Vdiff gnd GND sky130_fd_pr__nfet_01v8 L=0.5 W=12 nf=1 ad=3.48 as=3.48 pd=24.58 ps=24.58 nrd=0.0241666666666667
+ nrs=0.0241666666666667 sa=0 sb=0 sd=0 mult=1
XM1 net3 minus net1 VDD sky130_fd_pr__pfet_01v8_lvt L=1.5 W=2.644 nf=2 ad=0.38338 as=0.76676 pd=3.224 ps=6.448
+ nrd=0.109682299546142 nrs=0.109682299546142 sa=0 sb=0 sd=0 mult=5 m=5
XM3 Vdiff net3 gnd GND sky130_fd_pr__nfet_01v8 L=1.5 W=0.564 nf=1 ad=0.16356 as=0.16356 pd=1.708 ps=1.708 nrd=0.514184397163121
+ nrs=0.514184397163121 sa=0 sb=0 sd=0 mult=1
XM4 net1 net2 VDD VDD sky130_fd_pr__pfet_01v8 L=0.75 W=0.515 nf=1 ad=0.14935 as=0.14935 pd=1.61 ps=1.61 nrd=0.563106796116505
+ nrs=0.563106796116505 sa=0 sb=0 sd=0 mult=4 m=4
XM2 Vdiff plus net1 VDD sky130_fd_pr__pfet_01v8_lvt L=1.5 W=2.644 nf=2 ad=0.38338 as=0.76676 pd=3.224 ps=6.448
+ nrd=0.109682299546142 nrs=0.109682299546142 sa=0 sb=0 sd=0 mult=5 m=5
XR4 net4 Vdiff gnd sky130_fd_pr__res_xhigh_po_1p41 L=14.5 mult=1
XC3 out net4 sky130_fd_pr__cap_mim_m3_1 W=1 L=25 MF=20 m=20
XM7 net2 net2 VDD VDD sky130_fd_pr__pfet_01v8 L=0.75 W=0.515 nf=1 ad=0.14935 as=0.14935 pd=1.61 ps=1.61 nrd=0.563106796116505
+ nrs=0.563106796116505 sa=0 sb=0 sd=0 mult=4 m=4
XM5 out net2 VDD VDD sky130_fd_pr__pfet_01v8 L=0.75 W=0.515 nf=1 ad=0.14935 as=0.14935 pd=1.61 ps=1.61 nrd=0.563106796116505
+ nrs=0.563106796116505 sa=0 sb=0 sd=0 mult=4 m=4
XR8 net7 net2 gnd sky130_fd_pr__res_xhigh_po_1p41 L=11.75 mult=1
XR5 net6 net7 gnd sky130_fd_pr__res_xhigh_po_1p41 L=11.75 mult=1
XR6 net5 net6 gnd sky130_fd_pr__res_xhigh_po_1p41 L=11.75 mult=1
XR9 gnd net5 gnd sky130_fd_pr__res_xhigh_po_1p41 L=11.75 mult=1
.ends

* expanding   symbol:  mips_cpu/mips.sym # of pins=8
** sym_path: /pdk/sky130A/libs.tech/xschem/mips_cpu/mips.sym
** sch_path: /pdk/sky130A/libs.tech/xschem/mips_cpu/mips.sch
.subckt mips imem_addr[31] imem_addr[30] imem_addr[29] imem_addr[28] imem_addr[27] imem_addr[26] imem_addr[25] imem_addr[24]
+ imem_addr[23] imem_addr[22] imem_addr[21] imem_addr[20] imem_addr[19] imem_addr[18] imem_addr[17] imem_addr[16] imem_addr[15] imem_addr[14]
+ imem_addr[13] imem_addr[12] imem_addr[11] imem_addr[10] imem_addr[9] imem_addr[8] imem_addr[7] imem_addr[6] imem_addr[5] imem_addr[4]
+ imem_addr[3] imem_addr[2] imem_addr[1] imem_addr[0] clk dmem_we rst imem_data[31] imem_data[30] imem_data[29] imem_data[28] imem_data[27]
+ imem_data[26] imem_data[25] imem_data[24] imem_data[23] imem_data[22] imem_data[21] imem_data[20] imem_data[19] imem_data[18] imem_data[17]
+ imem_data[16] imem_data[15] imem_data[14] imem_data[13] imem_data[12] imem_data[11] imem_data[10] imem_data[9] imem_data[8] imem_data[7]
+ imem_data[6] imem_data[5] imem_data[4] imem_data[3] imem_data[2] imem_data[1] imem_data[0] dmem_addr[31] dmem_addr[30] dmem_addr[29]
+ dmem_addr[28] dmem_addr[27] dmem_addr[26] dmem_addr[25] dmem_addr[24] dmem_addr[23] dmem_addr[22] dmem_addr[21] dmem_addr[20] dmem_addr[19]
+ dmem_addr[18] dmem_addr[17] dmem_addr[16] dmem_addr[15] dmem_addr[14] dmem_addr[13] dmem_addr[12] dmem_addr[11] dmem_addr[10] dmem_addr[9]
+ dmem_addr[8] dmem_addr[7] dmem_addr[6] dmem_addr[5] dmem_addr[4] dmem_addr[3] dmem_addr[2] dmem_addr[1] dmem_addr[0] dmem_rdata[31]
+ dmem_rdata[30] dmem_rdata[29] dmem_rdata[28] dmem_rdata[27] dmem_rdata[26] dmem_rdata[25] dmem_rdata[24] dmem_rdata[23] dmem_rdata[22]
+ dmem_rdata[21] dmem_rdata[20] dmem_rdata[19] dmem_rdata[18] dmem_rdata[17] dmem_rdata[16] dmem_rdata[15] dmem_rdata[14] dmem_rdata[13]
+ dmem_rdata[12] dmem_rdata[11] dmem_rdata[10] dmem_rdata[9] dmem_rdata[8] dmem_rdata[7] dmem_rdata[6] dmem_rdata[5] dmem_rdata[4] dmem_rdata[3]
+ dmem_rdata[2] dmem_rdata[1] dmem_rdata[0] dmem_wdata[31] dmem_wdata[30] dmem_wdata[29] dmem_wdata[28] dmem_wdata[27] dmem_wdata[26]
+ dmem_wdata[25] dmem_wdata[24] dmem_wdata[23] dmem_wdata[22] dmem_wdata[21] dmem_wdata[20] dmem_wdata[19] dmem_wdata[18] dmem_wdata[17]
+ dmem_wdata[16] dmem_wdata[15] dmem_wdata[14] dmem_wdata[13] dmem_wdata[12] dmem_wdata[11] dmem_wdata[10] dmem_wdata[9] dmem_wdata[8]
+ dmem_wdata[7] dmem_wdata[6] dmem_wdata[5] dmem_wdata[4] dmem_wdata[3] dmem_wdata[2] dmem_wdata[1] dmem_wdata[0]
*.ipin clk
*.opin
*+ imem_addr[31],imem_addr[30],imem_addr[29],imem_addr[28],imem_addr[27],imem_addr[26],imem_addr[25],imem_addr[24],imem_addr[23],imem_addr[22],imem_addr[21],imem_addr[20],imem_addr[19],imem_addr[18],imem_addr[17],imem_addr[16],imem_addr[15],imem_addr[14],imem_addr[13],imem_addr[12],imem_addr[11],imem_addr[10],imem_addr[9],imem_addr[8],imem_addr[7],imem_addr[6],imem_addr[5],imem_addr[4],imem_addr[3],imem_addr[2],imem_addr[1],imem_addr[0]
*.ipin rst
*.ipin
*+ imem_data[31],imem_data[30],imem_data[29],imem_data[28],imem_data[27],imem_data[26],imem_data[25],imem_data[24],imem_data[23],imem_data[22],imem_data[21],imem_data[20],imem_data[19],imem_data[18],imem_data[17],imem_data[16],imem_data[15],imem_data[14],imem_data[13],imem_data[12],imem_data[11],imem_data[10],imem_data[9],imem_data[8],imem_data[7],imem_data[6],imem_data[5],imem_data[4],imem_data[3],imem_data[2],imem_data[1],imem_data[0]
*.ipin
*+ dmem_rdata[31],dmem_rdata[30],dmem_rdata[29],dmem_rdata[28],dmem_rdata[27],dmem_rdata[26],dmem_rdata[25],dmem_rdata[24],dmem_rdata[23],dmem_rdata[22],dmem_rdata[21],dmem_rdata[20],dmem_rdata[19],dmem_rdata[18],dmem_rdata[17],dmem_rdata[16],dmem_rdata[15],dmem_rdata[14],dmem_rdata[13],dmem_rdata[12],dmem_rdata[11],dmem_rdata[10],dmem_rdata[9],dmem_rdata[8],dmem_rdata[7],dmem_rdata[6],dmem_rdata[5],dmem_rdata[4],dmem_rdata[3],dmem_rdata[2],dmem_rdata[1],dmem_rdata[0]
*.opin dmem_we
*.opin
*+ dmem_addr[31],dmem_addr[30],dmem_addr[29],dmem_addr[28],dmem_addr[27],dmem_addr[26],dmem_addr[25],dmem_addr[24],dmem_addr[23],dmem_addr[22],dmem_addr[21],dmem_addr[20],dmem_addr[19],dmem_addr[18],dmem_addr[17],dmem_addr[16],dmem_addr[15],dmem_addr[14],dmem_addr[13],dmem_addr[12],dmem_addr[11],dmem_addr[10],dmem_addr[9],dmem_addr[8],dmem_addr[7],dmem_addr[6],dmem_addr[5],dmem_addr[4],dmem_addr[3],dmem_addr[2],dmem_addr[1],dmem_addr[0]
*.opin
*+ dmem_wdata[31],dmem_wdata[30],dmem_wdata[29],dmem_wdata[28],dmem_wdata[27],dmem_wdata[26],dmem_wdata[25],dmem_wdata[24],dmem_wdata[23],dmem_wdata[22],dmem_wdata[21],dmem_wdata[20],dmem_wdata[19],dmem_wdata[18],dmem_wdata[17],dmem_wdata[16],dmem_wdata[15],dmem_wdata[14],dmem_wdata[13],dmem_wdata[12],dmem_wdata[11],dmem_wdata[10],dmem_wdata[9],dmem_wdata[8],dmem_wdata[7],dmem_wdata[6],dmem_wdata[5],dmem_wdata[4],dmem_wdata[3],dmem_wdata[2],dmem_wdata[1],dmem_wdata[0]
xcontroller_inst imem_data[31] imem_data[30] imem_data[29] imem_data[28] imem_data[27] imem_data[26] imem_data[25] imem_data[24]
+ imem_data[23] imem_data[22] imem_data[21] imem_data[20] imem_data[19] imem_data[18] imem_data[17] imem_data[16] imem_data[15] imem_data[14]
+ imem_data[13] imem_data[12] imem_data[11] imem_data[10] imem_data[9] imem_data[8] imem_data[7] imem_data[6] imem_data[5] imem_data[4]
+ imem_data[3] imem_data[2] imem_data[1] imem_data[0] branch jump mem_to_reg dmem_we reg_dst reg_write alucontrol[2] alucontrol[1] alucontrol[0]
+ alu_src controller
xdatapath_inst clk rst alucontrol[2] alucontrol[1] alucontrol[0] alu_src branch jump mem_to_reg dmem_we imem_addr[31]
+ imem_addr[30] imem_addr[29] imem_addr[28] imem_addr[27] imem_addr[26] imem_addr[25] imem_addr[24] imem_addr[23] imem_addr[22] imem_addr[21]
+ imem_addr[20] imem_addr[19] imem_addr[18] imem_addr[17] imem_addr[16] imem_addr[15] imem_addr[14] imem_addr[13] imem_addr[12] imem_addr[11]
+ imem_addr[10] imem_addr[9] imem_addr[8] imem_addr[7] imem_addr[6] imem_addr[5] imem_addr[4] imem_addr[3] imem_addr[2] imem_addr[1] imem_addr[0]
+ reg_dst dmem_addr[31] dmem_addr[30] dmem_addr[29] dmem_addr[28] dmem_addr[27] dmem_addr[26] dmem_addr[25] dmem_addr[24] dmem_addr[23]
+ dmem_addr[22] dmem_addr[21] dmem_addr[20] dmem_addr[19] dmem_addr[18] dmem_addr[17] dmem_addr[16] dmem_addr[15] dmem_addr[14] dmem_addr[13]
+ dmem_addr[12] dmem_addr[11] dmem_addr[10] dmem_addr[9] dmem_addr[8] dmem_addr[7] dmem_addr[6] dmem_addr[5] dmem_addr[4] dmem_addr[3]
+ dmem_addr[2] dmem_addr[1] dmem_addr[0] reg_write dmem_wdata[31] dmem_wdata[30] dmem_wdata[29] dmem_wdata[28] dmem_wdata[27] dmem_wdata[26]
+ dmem_wdata[25] dmem_wdata[24] dmem_wdata[23] dmem_wdata[22] dmem_wdata[21] dmem_wdata[20] dmem_wdata[19] dmem_wdata[18] dmem_wdata[17]
+ dmem_wdata[16] dmem_wdata[15] dmem_wdata[14] dmem_wdata[13] dmem_wdata[12] dmem_wdata[11] dmem_wdata[10] dmem_wdata[9] dmem_wdata[8]
+ dmem_wdata[7] dmem_wdata[6] dmem_wdata[5] dmem_wdata[4] dmem_wdata[3] dmem_wdata[2] dmem_wdata[1] dmem_wdata[0] imem_data[31] imem_data[30]
+ imem_data[29] imem_data[28] imem_data[27] imem_data[26] imem_data[25] imem_data[24] imem_data[23] imem_data[22] imem_data[21] imem_data[20]
+ imem_data[19] imem_data[18] imem_data[17] imem_data[16] imem_data[15] imem_data[14] imem_data[13] imem_data[12] imem_data[11] imem_data[10]
+ imem_data[9] imem_data[8] imem_data[7] imem_data[6] imem_data[5] imem_data[4] imem_data[3] imem_data[2] imem_data[1] imem_data[0]
+ dmem_rdata[31] dmem_rdata[30] dmem_rdata[29] dmem_rdata[28] dmem_rdata[27] dmem_rdata[26] dmem_rdata[25] dmem_rdata[24] dmem_rdata[23]
+ dmem_rdata[22] dmem_rdata[21] dmem_rdata[20] dmem_rdata[19] dmem_rdata[18] dmem_rdata[17] dmem_rdata[16] dmem_rdata[15] dmem_rdata[14]
+ dmem_rdata[13] dmem_rdata[12] dmem_rdata[11] dmem_rdata[10] dmem_rdata[9] dmem_rdata[8] dmem_rdata[7] dmem_rdata[6] dmem_rdata[5] dmem_rdata[4]
+ dmem_rdata[3] dmem_rdata[2] dmem_rdata[1] dmem_rdata[0] datapath
* noconn clk
* noconn rst
* noconn imem_data[31:0]
* noconn dmem_rdata[31:0]
* noconn imem_addr[31:0]
* noconn dmem_we
* noconn dmem_addr[31:0]
* noconn dmem_wdata[31:0]
.ends

* expanding   symbol:  mips_cpu/dmem.sym # of pins=5
** sym_path: /pdk/sky130A/libs.tech/xschem/mips_cpu/dmem.sym
** sch_path: /pdk/sky130A/libs.tech/xschem/mips_cpu/dmem.sch
.subckt dmem clk we rdata[31] rdata[30] rdata[29] rdata[28] rdata[27] rdata[26] rdata[25] rdata[24] rdata[23] rdata[22] rdata[21]
+ rdata[20] rdata[19] rdata[18] rdata[17] rdata[16] rdata[15] rdata[14] rdata[13] rdata[12] rdata[11] rdata[10] rdata[9] rdata[8] rdata[7]
+ rdata[6] rdata[5] rdata[4] rdata[3] rdata[2] rdata[1] rdata[0] addr[31] addr[30] addr[29] addr[28] addr[27] addr[26] addr[25] addr[24]
+ addr[23] addr[22] addr[21] addr[20] addr[19] addr[18] addr[17] addr[16] addr[15] addr[14] addr[13] addr[12] addr[11] addr[10] addr[9]
+ addr[8] addr[7] addr[6] addr[5] addr[4] addr[3] addr[2] addr[1] addr[0] wdata[31] wdata[30] wdata[29] wdata[28] wdata[27] wdata[26]
+ wdata[25] wdata[24] wdata[23] wdata[22] wdata[21] wdata[20] wdata[19] wdata[18] wdata[17] wdata[16] wdata[15] wdata[14] wdata[13] wdata[12]
+ wdata[11] wdata[10] wdata[9] wdata[8] wdata[7] wdata[6] wdata[5] wdata[4] wdata[3] wdata[2] wdata[1] wdata[0]
*.ipin clk
*.ipin we
*.ipin
*+ addr[31],addr[30],addr[29],addr[28],addr[27],addr[26],addr[25],addr[24],addr[23],addr[22],addr[21],addr[20],addr[19],addr[18],addr[17],addr[16],addr[15],addr[14],addr[13],addr[12],addr[11],addr[10],addr[9],addr[8],addr[7],addr[6],addr[5],addr[4],addr[3],addr[2],addr[1],addr[0]
*.ipin
*+ wdata[31],wdata[30],wdata[29],wdata[28],wdata[27],wdata[26],wdata[25],wdata[24],wdata[23],wdata[22],wdata[21],wdata[20],wdata[19],wdata[18],wdata[17],wdata[16],wdata[15],wdata[14],wdata[13],wdata[12],wdata[11],wdata[10],wdata[9],wdata[8],wdata[7],wdata[6],wdata[5],wdata[4],wdata[3],wdata[2],wdata[1],wdata[0]
*.opin
*+ rdata[31],rdata[30],rdata[29],rdata[28],rdata[27],rdata[26],rdata[25],rdata[24],rdata[23],rdata[22],rdata[21],rdata[20],rdata[19],rdata[18],rdata[17],rdata[16],rdata[15],rdata[14],rdata[13],rdata[12],rdata[11],rdata[10],rdata[9],rdata[8],rdata[7],rdata[6],rdata[5],rdata[4],rdata[3],rdata[2],rdata[1],rdata[0]
* noconn rdata[31:0]
* noconn clk
* noconn we
* noconn addr[31:0]
* noconn wdata[31:0]
.ends

* expanding   symbol:  mips_cpu/imem.sym # of pins=2
** sym_path: /pdk/sky130A/libs.tech/xschem/mips_cpu/imem.sym
** sch_path: /pdk/sky130A/libs.tech/xschem/mips_cpu/imem.sch
.subckt imem data[31] data[30] data[29] data[28] data[27] data[26] data[25] data[24] data[23] data[22] data[21] data[20] data[19]
+ data[18] data[17] data[16] data[15] data[14] data[13] data[12] data[11] data[10] data[9] data[8] data[7] data[6] data[5] data[4] data[3]
+ data[2] data[1] data[0] addr[5] addr[4] addr[3] addr[2] addr[1] addr[0]
*.ipin addr[5],addr[4],addr[3],addr[2],addr[1],addr[0]
*.opin
*+ data[31],data[30],data[29],data[28],data[27],data[26],data[25],data[24],data[23],data[22],data[21],data[20],data[19],data[18],data[17],data[16],data[15],data[14],data[13],data[12],data[11],data[10],data[9],data[8],data[7],data[6],data[5],data[4],data[3],data[2],data[1],data[0]
* noconn data[31:0]
* noconn addr[5:0]
.ends

* expanding   symbol:  sky130_tests/bandgap_opamp.sym # of pins=8
** sym_path: /pdk/sky130A/libs.tech/xschem/sky130_tests/bandgap_opamp.sym
** sch_path: /pdk/sky130A/libs.tech/xschem/sky130_tests/bandgap_opamp.sch
.subckt bandgap_opamp EN_N MINUS PLUS DIFFOUT VCC VSS ADJ START
*.ipin PLUS
*.ipin MINUS
*.ipin EN_N
*.ipin VSS
*.ipin VCC
*.opin DIFFOUT
*.ipin ADJ
*.ipin START
C6 G1 0 2f
XM4 net7 EN_N VCC VCC sky130_fd_pr__pfet_01v8 L=6 W=2 nf=1 ad=0.58 as=0.58 pd=4.58 ps=4.58 nrd=0.145 nrs=0.145 sa=0 sb=0 sd=0
+ mult=1
XM18 G2 G1 VSS VSS sky130_fd_pr__nfet_01v8_lvt L=4 W=6 nf=1 ad=1.74 as=1.74 pd=12.58 ps=12.58 nrd=0.0483333333333333
+ nrs=0.0483333333333333 sa=0 sb=0 sd=0 mult=1
XM2 G1 G1 VSS VSS sky130_fd_pr__nfet_01v8_lvt L=4 W=6 nf=1 ad=1.74 as=1.74 pd=12.58 ps=12.58 nrd=0.0483333333333333
+ nrs=0.0483333333333333 sa=0 sb=0 sd=0 mult=1
XM20 G2 PLUS net8 VCC sky130_fd_pr__pfet_01v8_lvt L=2 W=8 nf=1 ad=2.32 as=2.32 pd=16.58 ps=16.58 nrd=0.03625 nrs=0.03625 sa=0 sb=0
+ sd=0 mult=1
XM6 G1 MINUS net9 VCC sky130_fd_pr__pfet_01v8_lvt L=2 W=8 nf=1 ad=2.32 as=2.32 pd=16.58 ps=16.58 nrd=0.03625 nrs=0.03625 sa=0 sb=0
+ sd=0 mult=1
v1 SP net9 0
.save i(v1)
C4 SP 0 2f
C1 G2 0 2f
C5 DIFFOUT 0 4f
XM11 DIFFOUT G2 net1 VSS sky130_fd_pr__nfet_01v8_lvt L=4 W=6 nf=1 ad=1.74 as=1.74 pd=12.58 ps=12.58 nrd=0.0483333333333333
+ nrs=0.0483333333333333 sa=0 sb=0 sd=0 mult=5 m=5
v2 SP net8 0
.save i(v2)
XM5 G1 DIFFOUT net10 VCC sky130_fd_pr__pfet_01v8_lvt L=2 W=8 nf=1 ad=2.32 as=2.32 pd=16.58 ps=16.58 nrd=0.03625 nrs=0.03625 sa=0
+ sb=0 sd=0 mult=1
v3 SP net10 0
.save i(v3)
v4 net1 VSS 0
.save i(v4)
v5 VCC net5 0
.save i(v5)
v6 net7 SP 0
.save i(v6)
XM7 DIFFOUT EN_N VSS VSS sky130_fd_pr__nfet_01v8 L=0.15 W=0.5 nf=1 ad=0.145 as=0.145 pd=1.58 ps=1.58 nrd=0.58 nrs=0.58 sa=0 sb=0
+ sd=0 mult=3 m=3
XM1 net2 EN_N VCC VCC sky130_fd_pr__pfet_01v8 L=6 W=1 nf=1 ad=0.29 as=0.29 pd=2.58 ps=2.58 nrd=0.29 nrs=0.29 sa=0 sb=0 sd=0 mult=1
XM8 net3 ADJ net2 VCC sky130_fd_pr__pfet_01v8_lvt L=1 W=1 nf=1 ad=0.29 as=0.29 pd=2.58 ps=2.58 nrd=0.29 nrs=0.29 sa=0 sb=0 sd=0
+ mult=1
XM9 net3 ADJ net4 VSS sky130_fd_pr__nfet_01v8 L=1 W=0.5 nf=1 ad=0.145 as=0.145 pd=1.58 ps=1.58 nrd=0.58 nrs=0.58 sa=0 sb=0 sd=0
+ mult=1
XM10 net4 VCC VSS VSS sky130_fd_pr__nfet_01v8 L=6 W=0.5 nf=1 ad=0.145 as=0.145 pd=1.58 ps=1.58 nrd=0.58 nrs=0.58 sa=0 sb=0 sd=0
+ mult=1
x1 START_N START VCC VSS not W_N=1 L_N=0.15 W_P=2 L_P=0.15
x3 G2 net3 START START_N VCC VSS passgate_nlvt W_N=0.5 L_N=0.35 W_P=0.5 L_P=0.35
XM3 DIFFOUT EN_N net5 VCC sky130_fd_pr__pfet_01v8 L=6 W=2 nf=1 ad=0.58 as=0.58 pd=4.58 ps=4.58 nrd=0.145 nrs=0.145 sa=0 sb=0 sd=0
+ mult=2 m=2
XC2 net6 G2 sky130_fd_pr__cap_mim_m3_2 W=5 L=5 MF=8 m=8
XR5 net6 DIFFOUT VSS sky130_fd_pr__res_xhigh_po_0p69 L=5 mult=1
.save v(g2)
.ends

* expanding   symbol:  sky130_tests/adder_64bit.sym # of pins=7
** sym_path: /pdk/sky130A/libs.tech/xschem/sky130_tests/adder_64bit.sym
** sch_path: /pdk/sky130A/libs.tech/xschem/sky130_tests/adder_64bit.sch
.subckt adder_64bit A[63] A[62] A[61] A[60] A[59] A[58] A[57] A[56] A[55] A[54] A[53] A[52] A[51] A[50] A[49] A[48] A[47] A[46]
+ A[45] A[44] A[43] A[42] A[41] A[40] A[39] A[38] A[37] A[36] A[35] A[34] A[33] A[32] A[31] A[30] A[29] A[28] A[27] A[26] A[25] A[24]
+ A[23] A[22] A[21] A[20] A[19] A[18] A[17] A[16] A[15] A[14] A[13] A[12] A[11] A[10] A[9] A[8] A[7] A[6] A[5] A[4] A[3] A[2] A[1] A[0]
+ S[63] S[62] S[61] S[60] S[59] S[58] S[57] S[56] S[55] S[54] S[53] S[52] S[51] S[50] S[49] S[48] S[47] S[46] S[45] S[44] S[43] S[42]
+ S[41] S[40] S[39] S[38] S[37] S[36] S[35] S[34] S[33] S[32] S[31] S[30] S[29] S[28] S[27] S[26] S[25] S[24] S[23] S[22] S[21] S[20]
+ S[19] S[18] S[17] S[16] S[15] S[14] S[13] S[12] S[11] S[10] S[9] S[8] S[7] S[6] S[5] S[4] S[3] S[2] S[1] S[0] B[63] B[62] B[61] B[60]
+ B[59] B[58] B[57] B[56] B[55] B[54] B[53] B[52] B[51] B[50] B[49] B[48] B[47] B[46] B[45] B[44] B[43] B[42] B[41] B[40] B[39] B[38]
+ B[37] B[36] B[35] B[34] B[33] B[32] B[31] B[30] B[29] B[28] B[27] B[26] B[25] B[24] B[23] B[22] B[21] B[20] B[19] B[18] B[17] B[16]
+ B[15] B[14] B[13] B[12] B[11] B[10] B[9] B[8] B[7] B[6] B[5] B[4] B[3] B[2] B[1] B[0] COUT SG CIN SP
*.ipin
*+ A[63],A[62],A[61],A[60],A[59],A[58],A[57],A[56],A[55],A[54],A[53],A[52],A[51],A[50],A[49],A[48],A[47],A[46],A[45],A[44],A[43],A[42],A[41],A[40],A[39],A[38],A[37],A[36],A[35],A[34],A[33],A[32],A[31],A[30],A[29],A[28],A[27],A[26],A[25],A[24],A[23],A[22],A[21],A[20],A[19],A[18],A[17],A[16],A[15],A[14],A[13],A[12],A[11],A[10],A[9],A[8],A[7],A[6],A[5],A[4],A[3],A[2],A[1],A[0]
*.ipin
*+ B[63],B[62],B[61],B[60],B[59],B[58],B[57],B[56],B[55],B[54],B[53],B[52],B[51],B[50],B[49],B[48],B[47],B[46],B[45],B[44],B[43],B[42],B[41],B[40],B[39],B[38],B[37],B[36],B[35],B[34],B[33],B[32],B[31],B[30],B[29],B[28],B[27],B[26],B[25],B[24],B[23],B[22],B[21],B[20],B[19],B[18],B[17],B[16],B[15],B[14],B[13],B[12],B[11],B[10],B[9],B[8],B[7],B[6],B[5],B[4],B[3],B[2],B[1],B[0]
*.ipin CIN
*.opin
*+ S[63],S[62],S[61],S[60],S[59],S[58],S[57],S[56],S[55],S[54],S[53],S[52],S[51],S[50],S[49],S[48],S[47],S[46],S[45],S[44],S[43],S[42],S[41],S[40],S[39],S[38],S[37],S[36],S[35],S[34],S[33],S[32],S[31],S[30],S[29],S[28],S[27],S[26],S[25],S[24],S[23],S[22],S[21],S[20],S[19],S[18],S[17],S[16],S[15],S[14],S[13],S[12],S[11],S[10],S[9],S[8],S[7],S[6],S[5],S[4],S[3],S[2],S[1],S[0]
*.opin SP
*.opin SG
*.opin COUT
xadd16[3] A[63] A[62] A[61] A[60] A[59] A[58] A[57] A[56] A[55] A[54] A[53] A[52] A[51] A[50] A[49] A[48] S[63] S[62] S[61] S[60]
+ S[59] S[58] S[57] S[56] S[55] S[54] S[53] S[52] S[51] S[50] S[49] S[48] B[63] B[62] B[61] B[60] B[59] B[58] B[57] B[56] B[55] B[54]
+ B[53] B[52] B[51] B[50] B[49] B[48] net1 G[3] C3 P[3] adder_16bit
xadd16[2] A[47] A[46] A[45] A[44] A[43] A[42] A[41] A[40] A[39] A[38] A[37] A[36] A[35] A[34] A[33] A[32] S[47] S[46] S[45] S[44]
+ S[43] S[42] S[41] S[40] S[39] S[38] S[37] S[36] S[35] S[34] S[33] S[32] B[47] B[46] B[45] B[44] B[43] B[42] B[41] B[40] B[39] B[38]
+ B[37] B[36] B[35] B[34] B[33] B[32] net1 G[2] C2 P[2] adder_16bit
xadd16[1] A[31] A[30] A[29] A[28] A[27] A[26] A[25] A[24] A[23] A[22] A[21] A[20] A[19] A[18] A[17] A[16] S[31] S[30] S[29] S[28]
+ S[27] S[26] S[25] S[24] S[23] S[22] S[21] S[20] S[19] S[18] S[17] S[16] B[31] B[30] B[29] B[28] B[27] B[26] B[25] B[24] B[23] B[22]
+ B[21] B[20] B[19] B[18] B[17] B[16] net1 G[1] C1 P[1] adder_16bit
xadd16[0] A[15] A[14] A[13] A[12] A[11] A[10] A[9] A[8] A[7] A[6] A[5] A[4] A[3] A[2] A[1] A[0] S[15] S[14] S[13] S[12] S[11]
+ S[10] S[9] S[8] S[7] S[6] S[5] S[4] S[3] S[2] S[1] S[0] B[15] B[14] B[13] B[12] B[11] B[10] B[9] B[8] B[7] B[6] B[5] B[4] B[3] B[2]
+ B[1] B[0] net1 G[0] CIN P[0] adder_16bit
xcla SG SP C1 P[3] P[2] P[1] P[0] C2 G[3] G[2] G[1] G[0] C3 COUT CIN cla_4bits
* noconn #net1
.ends

* expanding   symbol:  sky130_tests/cla_4bits.sym # of pins=9
** sym_path: /pdk/sky130A/libs.tech/xschem/sky130_tests/cla_4bits.sym
** sch_path: /pdk/sky130A/libs.tech/xschem/sky130_tests/cla_4bits.sch
.subckt cla_4bits SG SP C1 P[3] P[2] P[1] P[0] C2 G[3] G[2] G[1] G[0] C3 C4 C0
*.ipin P[3],P[2],P[1],P[0]
*.ipin G[3],G[2],G[1],G[0]
*.ipin C0
*.opin C4
*.opin C3
*.opin C2
*.opin C1
*.opin SG
*.opin SP
x1 P[0] VSS VSS VCC VCC net4 sky130_fd_sc_hd__inv_1
x2 net5 VSS VSS VCC VCC C1 sky130_fd_sc_hd__inv_1
x3 P[1] VSS VSS VCC VCC net2 sky130_fd_sc_hd__inv_1
x4 net8 VSS VSS VCC VCC C3 sky130_fd_sc_hd__inv_1
x5 G[1] VSS VSS VCC VCC net3 sky130_fd_sc_hd__inv_1
x6 net12 VSS VSS VCC VCC net13 sky130_fd_sc_hd__inv_1
x7 G[1] P[2] G[2] VSS VSS VCC VCC net12 sky130_fd_sc_hd__a21oi_1
x8 P[3] net13 G[3] VSS VSS VCC VCC net14 sky130_fd_sc_hd__a21oi_1
x9 C0 P[0] G[0] VSS VSS VCC VCC net5 sky130_fd_sc_hd__a21oi_1
x10 P[2] C2 G[2] VSS VSS VCC VCC net8 sky130_fd_sc_hd__a21oi_1
x11 G[0] VSS VSS VCC VCC net1 sky130_fd_sc_hd__inv_1
x12 net2 net5 net3 VSS VSS VCC VCC C2 sky130_fd_sc_hd__o21ai_1
x13 net5 net10 net14 VSS VSS VCC VCC C4 sky130_fd_sc_hd__o21ai_1
x14 net1 net10 net14 VSS VSS VCC VCC SG sky130_fd_sc_hd__o21ai_1
x15 net4 net10 VSS VSS VCC VCC SP sky130_fd_sc_hd__nor2_1
x16 P[1] P[2] P[3] VSS VSS VCC VCC net10 sky130_fd_sc_hd__nand3_1
C2 net4 0 5f
C1 net10 0 5f
C3 net1 0 5f
C4 net14 0 5f
C5 net2 0 5f
C6 net5 0 5f
C7 net3 0 5f
C8 net8 0 5f
C9 net13 0 5f
C10 net12 0 5f
C19[3] P[3] 0 5f
C19[2] P[2] 0 5f
C19[1] P[1] 0 5f
C19[0] P[0] 0 5f
C18[3] G[3] 0 5f
C18[2] G[2] 0 5f
C18[1] G[1] 0 5f
C18[0] G[0] 0 5f
C17 C0 0 5f
.ends

* expanding   symbol:  sky130_tests/adder_16bit.sym # of pins=7
** sym_path: /pdk/sky130A/libs.tech/xschem/sky130_tests/adder_16bit.sym
** sch_path: /pdk/sky130A/libs.tech/xschem/sky130_tests/adder_16bit.sch
.subckt adder_16bit A[15] A[14] A[13] A[12] A[11] A[10] A[9] A[8] A[7] A[6] A[5] A[4] A[3] A[2] A[1] A[0] S[15] S[14] S[13] S[12]
+ S[11] S[10] S[9] S[8] S[7] S[6] S[5] S[4] S[3] S[2] S[1] S[0] B[15] B[14] B[13] B[12] B[11] B[10] B[9] B[8] B[7] B[6] B[5] B[4] B[3]
+ B[2] B[1] B[0] COUT SG CIN SP
*.ipin A[15],A[14],A[13],A[12],A[11],A[10],A[9],A[8],A[7],A[6],A[5],A[4],A[3],A[2],A[1],A[0]
*.ipin B[15],B[14],B[13],B[12],B[11],B[10],B[9],B[8],B[7],B[6],B[5],B[4],B[3],B[2],B[1],B[0]
*.ipin CIN
*.opin S[15],S[14],S[13],S[12],S[11],S[10],S[9],S[8],S[7],S[6],S[5],S[4],S[3],S[2],S[1],S[0]
*.opin SP
*.opin SG
*.opin COUT
xadd4[3] A[15] A[14] A[13] A[12] S[15] S[14] S[13] S[12] B[15] B[14] B[13] B[12] net1 G[3] C3 P[3] adder_4bit
xadd4[2] A[11] A[10] A[9] A[8] S[11] S[10] S[9] S[8] B[11] B[10] B[9] B[8] net1 G[2] C2 P[2] adder_4bit
xadd4[1] A[7] A[6] A[5] A[4] S[7] S[6] S[5] S[4] B[7] B[6] B[5] B[4] net1 G[1] C1 P[1] adder_4bit
xadd4[0] A[3] A[2] A[1] A[0] S[3] S[2] S[1] S[0] B[3] B[2] B[1] B[0] net1 G[0] CIN P[0] adder_4bit
xcla SG SP C1 P[3] P[2] P[1] P[0] C2 G[3] G[2] G[1] G[0] C3 COUT CIN cla_4bits
* noconn #net1
.ends

* expanding   symbol:  sky130_tests/cla_2bits.sym # of pins=7
** sym_path: /pdk/sky130A/libs.tech/xschem/sky130_tests/cla_2bits.sym
** sch_path: /pdk/sky130A/libs.tech/xschem/sky130_tests/cla_2bits.sch
.subckt cla_2bits SG SP C1 P[1] P[0] C2 G[1] G[0] C0
*.ipin P[1],P[0]
*.ipin G[1],G[0]
*.ipin C0
*.opin C2
*.opin C1
*.opin SG
*.opin SP
x17 G[1] VSS VSS VCC VCC net1 sky130_fd_sc_hd__inv_1
x18 P[0] C0 G[0] VSS VSS VCC VCC net3 sky130_fd_sc_hd__a21oi_1
C17 net1 0 5f
C18 net3 0 5f
x19 G[0] P[1] VSS VSS VCC VCC net2 sky130_fd_sc_hd__nand2_1
C19 net2 0 5f
x20 P[1] P[0] C0 VSS VSS VCC VCC net4 sky130_fd_sc_hd__nand3_1
C20 net4 0 5f
x21 net1 net2 VSS VSS VCC VCC SG sky130_fd_sc_hd__nand2_1
x22 P[1] P[0] VSS VSS VCC VCC SP sky130_fd_sc_hd__and2_1
x23 net3 VSS VSS VCC VCC C1 sky130_fd_sc_hd__inv_1
x24 net1 net2 net4 VSS VSS VCC VCC C2 sky130_fd_sc_hd__nand3_1
.ends

* expanding   symbol:  sky130_tests/diode_ngspice.sym # of pins=2
** sym_path: /pdk/sky130A/libs.tech/xschem/sky130_tests/diode_ngspice.sym
** sch_path: /pdk/sky130A/libs.tech/xschem/sky130_tests/diode_ngspice.sch
.subckt diode_ngspice plus minus   Roff=1e9 Ron=0.1
*.iopin plus
*.iopin minus
Vm mn minus 0
.save i(vm)
Vp plus pn 0
.save i(vp)
B1 pn mn I = 'v(pn,mn) > 0 ? v(pn,mn) / Ron : v(pn,mn) / Roff'
.ends

* expanding   symbol:  mips_cpu/controller.sym # of pins=9
** sym_path: /pdk/sky130A/libs.tech/xschem/mips_cpu/controller.sym
** sch_path: /pdk/sky130A/libs.tech/xschem/mips_cpu/controller.sch
.subckt controller instr[31] instr[30] instr[29] instr[28] instr[27] instr[26] instr[25] instr[24] instr[23] instr[22] instr[21]
+ instr[20] instr[19] instr[18] instr[17] instr[16] instr[15] instr[14] instr[13] instr[12] instr[11] instr[10] instr[9] instr[8] instr[7]
+ instr[6] instr[5] instr[4] instr[3] instr[2] instr[1] instr[0] branch jump mem_to_reg mem_write reg_dst reg_write alucontrol[2]
+ alucontrol[1] alucontrol[0] alu_src
*.ipin
*+ instr[31],instr[30],instr[29],instr[28],instr[27],instr[26],instr[25],instr[24],instr[23],instr[22],instr[21],instr[20],instr[19],instr[18],instr[17],instr[16],instr[15],instr[14],instr[13],instr[12],instr[11],instr[10],instr[9],instr[8],instr[7],instr[6],instr[5],instr[4],instr[3],instr[2],instr[1],instr[0]
*.opin alucontrol[2],alucontrol[1],alucontrol[0]
*.opin branch
*.opin jump
*.opin mem_to_reg
*.opin mem_write
*.opin reg_dst
*.opin reg_write
*.opin alu_src
xmaindec_inst instr[31] instr[30] instr[29] instr[28] instr[27] instr[26] instr[25] instr[24] instr[23] instr[22] instr[21]
+ instr[20] instr[19] instr[18] instr[17] instr[16] instr[15] instr[14] instr[13] instr[12] instr[11] instr[10] instr[9] instr[8] instr[7]
+ instr[6] instr[5] instr[4] instr[3] instr[2] instr[1] instr[0] branch jump mem_to_reg mem_write reg_dst reg_write alu_src maindec
xaludec_inst instr[31] instr[30] instr[29] instr[28] instr[27] instr[26] instr[25] instr[24] instr[23] instr[22] instr[21]
+ instr[20] instr[19] instr[18] instr[17] instr[16] instr[15] instr[14] instr[13] instr[12] instr[11] instr[10] instr[9] instr[8] instr[7]
+ instr[6] instr[5] instr[4] instr[3] instr[2] instr[1] instr[0] alucontrol[2] alucontrol[1] alucontrol[0] aludec
* noconn branch
* noconn jump
* noconn mem_to_reg
* noconn mem_write
* noconn reg_dst
* noconn reg_write
* noconn alucontrol[2:0]
* noconn alu_src
* noconn instr[31:0]
.ends

* expanding   symbol:  mips_cpu/datapath.sym # of pins=15
** sym_path: /pdk/sky130A/libs.tech/xschem/mips_cpu/datapath.sym
** sch_path: /pdk/sky130A/libs.tech/xschem/mips_cpu/datapath.sch
.subckt datapath clk rst alucontrol[2] alucontrol[1] alucontrol[0] alu_src branch jump mem_to_reg mem_write pc[31] pc[30] pc[29]
+ pc[28] pc[27] pc[26] pc[25] pc[24] pc[23] pc[22] pc[21] pc[20] pc[19] pc[18] pc[17] pc[16] pc[15] pc[14] pc[13] pc[12] pc[11] pc[10]
+ pc[9] pc[8] pc[7] pc[6] pc[5] pc[4] pc[3] pc[2] pc[1] pc[0] reg_dst alu_result[31] alu_result[30] alu_result[29] alu_result[28]
+ alu_result[27] alu_result[26] alu_result[25] alu_result[24] alu_result[23] alu_result[22] alu_result[21] alu_result[20] alu_result[19]
+ alu_result[18] alu_result[17] alu_result[16] alu_result[15] alu_result[14] alu_result[13] alu_result[12] alu_result[11] alu_result[10]
+ alu_result[9] alu_result[8] alu_result[7] alu_result[6] alu_result[5] alu_result[4] alu_result[3] alu_result[2] alu_result[1] alu_result[0]
+ reg_write write_data[31] write_data[30] write_data[29] write_data[28] write_data[27] write_data[26] write_data[25] write_data[24]
+ write_data[23] write_data[22] write_data[21] write_data[20] write_data[19] write_data[18] write_data[17] write_data[16] write_data[15]
+ write_data[14] write_data[13] write_data[12] write_data[11] write_data[10] write_data[9] write_data[8] write_data[7] write_data[6] write_data[5]
+ write_data[4] write_data[3] write_data[2] write_data[1] write_data[0] instr[31] instr[30] instr[29] instr[28] instr[27] instr[26] instr[25]
+ instr[24] instr[23] instr[22] instr[21] instr[20] instr[19] instr[18] instr[17] instr[16] instr[15] instr[14] instr[13] instr[12] instr[11]
+ instr[10] instr[9] instr[8] instr[7] instr[6] instr[5] instr[4] instr[3] instr[2] instr[1] instr[0] read_data[31] read_data[30]
+ read_data[29] read_data[28] read_data[27] read_data[26] read_data[25] read_data[24] read_data[23] read_data[22] read_data[21] read_data[20]
+ read_data[19] read_data[18] read_data[17] read_data[16] read_data[15] read_data[14] read_data[13] read_data[12] read_data[11] read_data[10]
+ read_data[9] read_data[8] read_data[7] read_data[6] read_data[5] read_data[4] read_data[3] read_data[2] read_data[1] read_data[0]
*.ipin clk
*.ipin rst
*.ipin alucontrol[2],alucontrol[1],alucontrol[0]
*.ipin alu_src
*.ipin branch
*.ipin jump
*.ipin mem_to_reg
*.ipin reg_dst
*.ipin reg_write
*.ipin
*+ instr[31],instr[30],instr[29],instr[28],instr[27],instr[26],instr[25],instr[24],instr[23],instr[22],instr[21],instr[20],instr[19],instr[18],instr[17],instr[16],instr[15],instr[14],instr[13],instr[12],instr[11],instr[10],instr[9],instr[8],instr[7],instr[6],instr[5],instr[4],instr[3],instr[2],instr[1],instr[0]
*.opin
*+ pc[31],pc[30],pc[29],pc[28],pc[27],pc[26],pc[25],pc[24],pc[23],pc[22],pc[21],pc[20],pc[19],pc[18],pc[17],pc[16],pc[15],pc[14],pc[13],pc[12],pc[11],pc[10],pc[9],pc[8],pc[7],pc[6],pc[5],pc[4],pc[3],pc[2],pc[1],pc[0]
*.ipin
*+ read_data[31],read_data[30],read_data[29],read_data[28],read_data[27],read_data[26],read_data[25],read_data[24],read_data[23],read_data[22],read_data[21],read_data[20],read_data[19],read_data[18],read_data[17],read_data[16],read_data[15],read_data[14],read_data[13],read_data[12],read_data[11],read_data[10],read_data[9],read_data[8],read_data[7],read_data[6],read_data[5],read_data[4],read_data[3],read_data[2],read_data[1],read_data[0]
*.opin
*+ alu_result[31],alu_result[30],alu_result[29],alu_result[28],alu_result[27],alu_result[26],alu_result[25],alu_result[24],alu_result[23],alu_result[22],alu_result[21],alu_result[20],alu_result[19],alu_result[18],alu_result[17],alu_result[16],alu_result[15],alu_result[14],alu_result[13],alu_result[12],alu_result[11],alu_result[10],alu_result[9],alu_result[8],alu_result[7],alu_result[6],alu_result[5],alu_result[4],alu_result[3],alu_result[2],alu_result[1],alu_result[0]
*.opin
*+ write_data[31],write_data[30],write_data[29],write_data[28],write_data[27],write_data[26],write_data[25],write_data[24],write_data[23],write_data[22],write_data[21],write_data[20],write_data[19],write_data[18],write_data[17],write_data[16],write_data[15],write_data[14],write_data[13],write_data[12],write_data[11],write_data[10],write_data[9],write_data[8],write_data[7],write_data[6],write_data[5],write_data[4],write_data[3],write_data[2],write_data[1],write_data[0]
*.ipin mem_write
xregfile_inst clk instr[25] instr[24] instr[23] instr[22] instr[21] instr[20] instr[19] instr[18] instr[17] instr[16]
+ reg_data1[31] reg_data1[30] reg_data1[29] reg_data1[28] reg_data1[27] reg_data1[26] reg_data1[25] reg_data1[24] reg_data1[23] reg_data1[22]
+ reg_data1[21] reg_data1[20] reg_data1[19] reg_data1[18] reg_data1[17] reg_data1[16] reg_data1[15] reg_data1[14] reg_data1[13] reg_data1[12]
+ reg_data1[11] reg_data1[10] reg_data1[9] reg_data1[8] reg_data1[7] reg_data1[6] reg_data1[5] reg_data1[4] reg_data1[3] reg_data1[2]
+ reg_data1[1] reg_data1[0] reg_write reg_data2[31] reg_data2[30] reg_data2[29] reg_data2[28] reg_data2[27] reg_data2[26] reg_data2[25]
+ reg_data2[24] reg_data2[23] reg_data2[22] reg_data2[21] reg_data2[20] reg_data2[19] reg_data2[18] reg_data2[17] reg_data2[16] reg_data2[15]
+ reg_data2[14] reg_data2[13] reg_data2[12] reg_data2[11] reg_data2[10] reg_data2[9] reg_data2[8] reg_data2[7] reg_data2[6] reg_data2[5]
+ reg_data2[4] reg_data2[3] reg_data2[2] reg_data2[1] reg_data2[0] write_reg[4] write_reg[3] write_reg[2] write_reg[1] write_reg[0] result[31]
+ result[30] result[29] result[28] result[27] result[26] result[25] result[24] result[23] result[22] result[21] result[20] result[19]
+ result[18] result[17] result[16] result[15] result[14] result[13] result[12] result[11] result[10] result[9] result[8] result[7] result[6]
+ result[5] result[4] result[3] result[2] result[1] result[0] regfile
xalu_inst src_a[31] src_a[30] src_a[29] src_a[28] src_a[27] src_a[26] src_a[25] src_a[24] src_a[23] src_a[22] src_a[21] src_a[20]
+ src_a[19] src_a[18] src_a[17] src_a[16] src_a[15] src_a[14] src_a[13] src_a[12] src_a[11] src_a[10] src_a[9] src_a[8] src_a[7] src_a[6]
+ src_a[5] src_a[4] src_a[3] src_a[2] src_a[1] src_a[0] zero src_b[31] src_b[30] src_b[29] src_b[28] src_b[27] src_b[26] src_b[25] src_b[24]
+ src_b[23] src_b[22] src_b[21] src_b[20] src_b[19] src_b[18] src_b[17] src_b[16] src_b[15] src_b[14] src_b[13] src_b[12] src_b[11] src_b[10]
+ src_b[9] src_b[8] src_b[7] src_b[6] src_b[5] src_b[4] src_b[3] src_b[2] src_b[1] src_b[0] c_out alu_out[31] alu_out[30] alu_out[29]
+ alu_out[28] alu_out[27] alu_out[26] alu_out[25] alu_out[24] alu_out[23] alu_out[22] alu_out[21] alu_out[20] alu_out[19] alu_out[18]
+ alu_out[17] alu_out[16] alu_out[15] alu_out[14] alu_out[13] alu_out[12] alu_out[11] alu_out[10] alu_out[9] alu_out[8] alu_out[7] alu_out[6]
+ alu_out[5] alu_out[4] alu_out[3] alu_out[2] alu_out[1] alu_out[0] alucontrol[2] alucontrol[1] alucontrol[0] alu
xsign_extend_inst instr[15] instr[14] instr[13] instr[12] instr[11] instr[10] instr[9] instr[8] instr[7] instr[6] instr[5]
+ instr[4] instr[3] instr[2] instr[1] instr[0] imm_ext[31] imm_ext[30] imm_ext[29] imm_ext[28] imm_ext[27] imm_ext[26] imm_ext[25]
+ imm_ext[24] imm_ext[23] imm_ext[22] imm_ext[21] imm_ext[20] imm_ext[19] imm_ext[18] imm_ext[17] imm_ext[16] imm_ext[15] imm_ext[14]
+ imm_ext[13] imm_ext[12] imm_ext[11] imm_ext[10] imm_ext[9] imm_ext[8] imm_ext[7] imm_ext[6] imm_ext[5] imm_ext[4] imm_ext[3] imm_ext[2]
+ imm_ext[1] imm_ext[0] sign_extend
* noconn clk
* noconn rst
* noconn alucontrol[2:0]
* noconn alu_src
* noconn branch
* noconn jump
* noconn mem_to_reg
* noconn mem_write
* noconn reg_dst
* noconn reg_write
* noconn instr[31:0]
* noconn read_data[31:0]
* noconn pc[31:0]
* noconn write_data[31:0]
* noconn alu_result[31:0]
* noconn alu_out[31:0]
* noconn src_a[31:0]
* noconn src_b[31:0]
* noconn imm_ext[31:0]
* noconn reg_data1[31:0]
* noconn reg_data2[31:0]
* noconn result[31:0]
* noconn c_out
* noconn zero
* noconn write_reg[4:0]
.ends

* expanding   symbol:  sky130_tests/passgate_nlvt.sym # of pins=4
** sym_path: /pdk/sky130A/libs.tech/xschem/sky130_tests/passgate_nlvt.sym
** sch_path: /pdk/sky130A/libs.tech/xschem/sky130_tests/passgate_nlvt.sch
.subckt passgate_nlvt Z A GP GN VCCBPIN VSSBPIN  W_N=1 L_N=0.35 W_P=1 L_P=0.35
*.iopin A
*.iopin Z
*.ipin GP
*.ipin GN
XM1 Z GN A VSSBPIN sky130_fd_pr__nfet_01v8_lvt L=L_N W=W_N nf=1 ad='int((1 + 1)/2) * W_N / 1 * 0.29' as='int((1 + 2)/2) * W_N / 1 * 0.29'
+ pd='2*int((1 + 1)/2) * (W_N / 1 + 0.29)' ps='2*int((1 + 2)/2) * (W_N / 1 + 0.29)' nrd='0.29 / W_N ' nrs='0.29 / W_N ' sa=0 sb=0 sd=0
+ mult=1
XM2 Z GP A VCCBPIN sky130_fd_pr__pfet_01v8_lvt L=L_P W=W_P nf=1 ad='int((1 + 1)/2) * W_P / 1 * 0.29' as='int((1 + 2)/2) * W_P / 1 * 0.29'
+ pd='2*int((1 + 1)/2) * (W_P / 1 + 0.29)' ps='2*int((1 + 2)/2) * (W_P / 1 + 0.29)' nrd='0.29 / W_P ' nrs='0.29 / W_P ' sa=0 sb=0 sd=0
+ mult=1
* noconn VCCBPIN
* noconn VSSBPIN
.ends

* expanding   symbol:  sky130_tests/adder_4bit.sym # of pins=7
** sym_path: /pdk/sky130A/libs.tech/xschem/sky130_tests/adder_4bit.sym
** sch_path: /pdk/sky130A/libs.tech/xschem/sky130_tests/adder_4bit.sch
.subckt adder_4bit A[3] A[2] A[1] A[0] S[3] S[2] S[1] S[0] B[3] B[2] B[1] B[0] COUT SG CIN SP
*.ipin A[3],A[2],A[1],A[0]
*.ipin B[3],B[2],B[1],B[0]
*.ipin CIN
*.opin S[3],S[2],S[1],S[0]
*.opin SP
*.opin SG
*.opin COUT
xadd1[3] S[3] A[3] B[3] G[3] C3 P[3] adder_1bit
xadd1[2] S[2] A[2] B[2] G[2] C2 P[2] adder_1bit
xadd1[1] S[1] A[1] B[1] G[1] C1 P[1] adder_1bit
xadd1[0] S[0] A[0] B[0] G[0] CIN P[0] adder_1bit
xcla SG SP C1 P[3] P[2] P[1] P[0] C2 G[3] G[2] G[1] G[0] C3 COUT CIN cla_4bits
.ends

* expanding   symbol:  mips_cpu/maindec.sym # of pins=8
** sym_path: /pdk/sky130A/libs.tech/xschem/mips_cpu/maindec.sym
** sch_path: /pdk/sky130A/libs.tech/xschem/mips_cpu/maindec.sch
.subckt maindec instr[31] instr[30] instr[29] instr[28] instr[27] instr[26] instr[25] instr[24] instr[23] instr[22] instr[21]
+ instr[20] instr[19] instr[18] instr[17] instr[16] instr[15] instr[14] instr[13] instr[12] instr[11] instr[10] instr[9] instr[8] instr[7]
+ instr[6] instr[5] instr[4] instr[3] instr[2] instr[1] instr[0] branch jump mem_to_reg mem_write reg_dst reg_write alu_src
*.ipin
*+ instr[31],instr[30],instr[29],instr[28],instr[27],instr[26],instr[25],instr[24],instr[23],instr[22],instr[21],instr[20],instr[19],instr[18],instr[17],instr[16],instr[15],instr[14],instr[13],instr[12],instr[11],instr[10],instr[9],instr[8],instr[7],instr[6],instr[5],instr[4],instr[3],instr[2],instr[1],instr[0]
*.opin branch
*.opin jump
*.opin mem_to_reg
*.opin mem_write
*.opin reg_dst
*.opin reg_write
*.opin alu_src
* noconn branch
* noconn jump
* noconn mem_to_reg
* noconn mem_write
* noconn reg_dst
* noconn reg_write
* noconn alu_src
* noconn instr[31:0]
.ends

* expanding   symbol:  mips_cpu/aludec.sym # of pins=2
** sym_path: /pdk/sky130A/libs.tech/xschem/mips_cpu/aludec.sym
** sch_path: /pdk/sky130A/libs.tech/xschem/mips_cpu/aludec.sch
.subckt aludec instr[31] instr[30] instr[29] instr[28] instr[27] instr[26] instr[25] instr[24] instr[23] instr[22] instr[21]
+ instr[20] instr[19] instr[18] instr[17] instr[16] instr[15] instr[14] instr[13] instr[12] instr[11] instr[10] instr[9] instr[8] instr[7]
+ instr[6] instr[5] instr[4] instr[3] instr[2] instr[1] instr[0] alucontrol[2] alucontrol[1] alucontrol[0]
*.ipin
*+ instr[31],instr[30],instr[29],instr[28],instr[27],instr[26],instr[25],instr[24],instr[23],instr[22],instr[21],instr[20],instr[19],instr[18],instr[17],instr[16],instr[15],instr[14],instr[13],instr[12],instr[11],instr[10],instr[9],instr[8],instr[7],instr[6],instr[5],instr[4],instr[3],instr[2],instr[1],instr[0]
*.opin alucontrol[2],alucontrol[1],alucontrol[0]
* noconn alucontrol[2:0]
* noconn instr[31:0]
.ends

* expanding   symbol:  mips_cpu/regfile.sym # of pins=8
** sym_path: /pdk/sky130A/libs.tech/xschem/mips_cpu/regfile.sym
** sch_path: /pdk/sky130A/libs.tech/xschem/mips_cpu/regfile.sch
.subckt regfile clk addr1[4] addr1[3] addr1[2] addr1[1] addr1[0] addr2[4] addr2[3] addr2[2] addr2[1] addr2[0] data1[31] data1[30]
+ data1[29] data1[28] data1[27] data1[26] data1[25] data1[24] data1[23] data1[22] data1[21] data1[20] data1[19] data1[18] data1[17] data1[16]
+ data1[15] data1[14] data1[13] data1[12] data1[11] data1[10] data1[9] data1[8] data1[7] data1[6] data1[5] data1[4] data1[3] data1[2]
+ data1[1] data1[0] rw data2[31] data2[30] data2[29] data2[28] data2[27] data2[26] data2[25] data2[24] data2[23] data2[22] data2[21]
+ data2[20] data2[19] data2[18] data2[17] data2[16] data2[15] data2[14] data2[13] data2[12] data2[11] data2[10] data2[9] data2[8] data2[7]
+ data2[6] data2[5] data2[4] data2[3] data2[2] data2[1] data2[0] addr3[4] addr3[3] addr3[2] addr3[1] addr3[0] wdata[31] wdata[30] wdata[29]
+ wdata[28] wdata[27] wdata[26] wdata[25] wdata[24] wdata[23] wdata[22] wdata[21] wdata[20] wdata[19] wdata[18] wdata[17] wdata[16] wdata[15]
+ wdata[14] wdata[13] wdata[12] wdata[11] wdata[10] wdata[9] wdata[8] wdata[7] wdata[6] wdata[5] wdata[4] wdata[3] wdata[2] wdata[1] wdata[0]
*.ipin clk
*.ipin addr1[4],addr1[3],addr1[2],addr1[1],addr1[0]
*.ipin addr2[4],addr2[3],addr2[2],addr2[1],addr2[0]
*.opin
*+ data1[31],data1[30],data1[29],data1[28],data1[27],data1[26],data1[25],data1[24],data1[23],data1[22],data1[21],data1[20],data1[19],data1[18],data1[17],data1[16],data1[15],data1[14],data1[13],data1[12],data1[11],data1[10],data1[9],data1[8],data1[7],data1[6],data1[5],data1[4],data1[3],data1[2],data1[1],data1[0]
*.opin
*+ data2[31],data2[30],data2[29],data2[28],data2[27],data2[26],data2[25],data2[24],data2[23],data2[22],data2[21],data2[20],data2[19],data2[18],data2[17],data2[16],data2[15],data2[14],data2[13],data2[12],data2[11],data2[10],data2[9],data2[8],data2[7],data2[6],data2[5],data2[4],data2[3],data2[2],data2[1],data2[0]
*.ipin rw
*.ipin addr3[4],addr3[3],addr3[2],addr3[1],addr3[0]
*.ipin
*+ wdata[31],wdata[30],wdata[29],wdata[28],wdata[27],wdata[26],wdata[25],wdata[24],wdata[23],wdata[22],wdata[21],wdata[20],wdata[19],wdata[18],wdata[17],wdata[16],wdata[15],wdata[14],wdata[13],wdata[12],wdata[11],wdata[10],wdata[9],wdata[8],wdata[7],wdata[6],wdata[5],wdata[4],wdata[3],wdata[2],wdata[1],wdata[0]
* noconn clk
* noconn addr1[4:0]
* noconn addr2[4:0]
* noconn rw
* noconn addr3[4:0]
* noconn wdata[31:0]
* noconn data1[31:0]
* noconn data2[31:0]
.ends

* expanding   symbol:  mips_cpu/alu.sym # of pins=6
** sym_path: /pdk/sky130A/libs.tech/xschem/mips_cpu/alu.sym
** sch_path: /pdk/sky130A/libs.tech/xschem/mips_cpu/alu.sch
.subckt alu a_in[31] a_in[30] a_in[29] a_in[28] a_in[27] a_in[26] a_in[25] a_in[24] a_in[23] a_in[22] a_in[21] a_in[20] a_in[19]
+ a_in[18] a_in[17] a_in[16] a_in[15] a_in[14] a_in[13] a_in[12] a_in[11] a_in[10] a_in[9] a_in[8] a_in[7] a_in[6] a_in[5] a_in[4] a_in[3]
+ a_in[2] a_in[1] a_in[0] zero b_in[31] b_in[30] b_in[29] b_in[28] b_in[27] b_in[26] b_in[25] b_in[24] b_in[23] b_in[22] b_in[21] b_in[20]
+ b_in[19] b_in[18] b_in[17] b_in[16] b_in[15] b_in[14] b_in[13] b_in[12] b_in[11] b_in[10] b_in[9] b_in[8] b_in[7] b_in[6] b_in[5] b_in[4]
+ b_in[3] b_in[2] b_in[1] b_in[0] c_out y_out[31] y_out[30] y_out[29] y_out[28] y_out[27] y_out[26] y_out[25] y_out[24] y_out[23] y_out[22]
+ y_out[21] y_out[20] y_out[19] y_out[18] y_out[17] y_out[16] y_out[15] y_out[14] y_out[13] y_out[12] y_out[11] y_out[10] y_out[9] y_out[8]
+ y_out[7] y_out[6] y_out[5] y_out[4] y_out[3] y_out[2] y_out[1] y_out[0] f_in[2] f_in[1] f_in[0]
*.ipin
*+ a_in[31],a_in[30],a_in[29],a_in[28],a_in[27],a_in[26],a_in[25],a_in[24],a_in[23],a_in[22],a_in[21],a_in[20],a_in[19],a_in[18],a_in[17],a_in[16],a_in[15],a_in[14],a_in[13],a_in[12],a_in[11],a_in[10],a_in[9],a_in[8],a_in[7],a_in[6],a_in[5],a_in[4],a_in[3],a_in[2],a_in[1],a_in[0]
*.opin zero
*.ipin
*+ b_in[31],b_in[30],b_in[29],b_in[28],b_in[27],b_in[26],b_in[25],b_in[24],b_in[23],b_in[22],b_in[21],b_in[20],b_in[19],b_in[18],b_in[17],b_in[16],b_in[15],b_in[14],b_in[13],b_in[12],b_in[11],b_in[10],b_in[9],b_in[8],b_in[7],b_in[6],b_in[5],b_in[4],b_in[3],b_in[2],b_in[1],b_in[0]
*.ipin f_in[2],f_in[1],f_in[0]
*.opin c_out
*.opin
*+ y_out[31],y_out[30],y_out[29],y_out[28],y_out[27],y_out[26],y_out[25],y_out[24],y_out[23],y_out[22],y_out[21],y_out[20],y_out[19],y_out[18],y_out[17],y_out[16],y_out[15],y_out[14],y_out[13],y_out[12],y_out[11],y_out[10],y_out[9],y_out[8],y_out[7],y_out[6],y_out[5],y_out[4],y_out[3],y_out[2],y_out[1],y_out[0]
* noconn zero
* noconn a_in[31:0]
* noconn b_in[31:0]
* noconn f_in[2:0]
* noconn c_out
* noconn y_out[31:0]
.ends

* expanding   symbol:  mips_cpu/sign_extend.sym # of pins=2
** sym_path: /pdk/sky130A/libs.tech/xschem/mips_cpu/sign_extend.sym
** sch_path: /pdk/sky130A/libs.tech/xschem/mips_cpu/sign_extend.sch
.subckt sign_extend idata[15] idata[14] idata[13] idata[12] idata[11] idata[10] idata[9] idata[8] idata[7] idata[6] idata[5]
+ idata[4] idata[3] idata[2] idata[1] idata[0] odata[31] odata[30] odata[29] odata[28] odata[27] odata[26] odata[25] odata[24] odata[23]
+ odata[22] odata[21] odata[20] odata[19] odata[18] odata[17] odata[16] odata[15] odata[14] odata[13] odata[12] odata[11] odata[10] odata[9]
+ odata[8] odata[7] odata[6] odata[5] odata[4] odata[3] odata[2] odata[1] odata[0]
*.opin
*+ odata[31],odata[30],odata[29],odata[28],odata[27],odata[26],odata[25],odata[24],odata[23],odata[22],odata[21],odata[20],odata[19],odata[18],odata[17],odata[16],odata[15],odata[14],odata[13],odata[12],odata[11],odata[10],odata[9],odata[8],odata[7],odata[6],odata[5],odata[4],odata[3],odata[2],odata[1],odata[0]
*.ipin
*+ idata[15],idata[14],idata[13],idata[12],idata[11],idata[10],idata[9],idata[8],idata[7],idata[6],idata[5],idata[4],idata[3],idata[2],idata[1],idata[0]
* noconn odata[31:0]
* noconn idata[15:0]
.ends

* expanding   symbol:  sky130_tests/adder_1bit.sym # of pins=6
** sym_path: /pdk/sky130A/libs.tech/xschem/sky130_tests/adder_1bit.sym
** sch_path: /pdk/sky130A/libs.tech/xschem/sky130_tests/adder_1bit.sch
.subckt adder_1bit S A B G CIN P
*.ipin A
*.ipin B
*.ipin CIN
*.opin S
*.opin P
*.opin G
x4 A B VSS VSS VCC VCC G sky130_fd_sc_hd__and2_1
x2 A B VSS VSS VCC VCC P sky130_fd_sc_hd__xor2_1
x3 P CIN VSS VSS VCC VCC S sky130_fd_sc_hd__xor2_1
C17 A 0 5f
C4 B 0 5f
C5 CIN 0 5f
.ends

.GLOBAL GND
.GLOBAL VDD
.GLOBAL VCC
.GLOBAL VSS
**** begin user architecture code
.MODEL SW1 SW
+ VT=1.0 VH=0.01
+ RON=10 ROFF=10MEG

.subckt diff_amp_cell OUT IN1 IN2
N1 out in1 in2 diff_amp_model
.ends diff_amp_cell

.model diff_amp_model diff_amp

.control
* following line specifies the location for the .osdi file so ngspice can use it.
pre_osdi /tmp/.xschem/xschem_library/diff_amp.osdi
.endc

.model integrator s_xfer(num_coeff=[1] den_coeff=[1 0] int_ic=[0] denormalized_freq=1e5)

**** end user architecture code
.end

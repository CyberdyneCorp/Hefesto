** sch_path: /work/input/nl12.sch
**.subckt nl12
R1 net1 net2 f00000001 f00000002 f00000003 f00000004 f00000005 f00000006 f00000007 f00000008 f00000009 f00000010 f00000011
+ f00000012 f00000013 f00000014 f00000015 f00000016 f00000017 f00000018
R2 net3 net4 {a01*b01} {a02*b02} {a03*b03} {a04*b04} {a05*b05} {a06*b06} {a07*b07} {a08*b08} {a09*b09} {a10*b10} {a11*b11} {a12*b12}
+ {a13*b13} {a14*b14} {a15*b15} {a16*b16} {a17*b17} {a18*b18}
.include /a/very/long/path/dddddddddddddddddddddddddddddddddddddddddddddddddddddddddddddddddddddddddddddddddddddddddddddddddddddddddddddddddddddddddddddddddddddddddddd/models.lib
* comment f00000001 f00000002 f00000003 f00000004 f00000005 f00000006 f00000007 f00000008 f00000009 f00000010 f00000011 f00000012
*+ f00000013 f00000014 f00000015 f00000016 f00000017 f00000018
R5 net9 net10 x'f00000001 f00000002 f00000003 f00000004 f00000005 f00000006 f00000007 f00000008 f00000009 f00000010 f00000011 f00000012 f00000013 f00000014 f00000015 f00000016 f00000017 f00000018
R6 net11 net12 f00000001 f00000002 f00000003 f00000004 f00000005 f00000006 f00000007 f00000008 f00000009 f00000010 f00000011 f00000012 f00000013 f00000014 f00000015 f00000016 f00000017 f00000018
**.ends
.end

** sch_path: /work/input/without/inv.sch
.subckt inv Y A
*.PININFO Y:O A:I
R1 Y A 1k
.ends

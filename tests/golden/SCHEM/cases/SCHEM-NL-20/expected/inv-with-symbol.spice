** sch_path: /work/input/with/inv.sch
.subckt inv A Y
*.PININFO Y:O A:I
R1 Y A 1k
.ends

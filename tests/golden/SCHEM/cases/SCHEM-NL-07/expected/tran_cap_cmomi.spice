** sch_path: /pdk/ihp-sg13g2/libs.tech/xschem/sg13g2_tests/tran_cap_cmomi.sch
**.subckt tran_cap_cmomi
V1 in GND pwl 0 0 1u 0 1.001u 1
R2 out GND 100k
XC1 out in cap_cmomi w=10.0e-6 l=70.0e-6 mmin=1 mmax=5 feed=double subblock=0 m=1 mm_ok=1
**** begin user architecture code

.control
save all
tran 1n 2u
write tran_cap_cmomi.raw
.endc

.lib /pdk/ihp-sg13g2/libs.tech/ngspice/models/cornerCAP.lib cap_typ

**** end user architecture code
**.ends
.GLOBAL GND
.end

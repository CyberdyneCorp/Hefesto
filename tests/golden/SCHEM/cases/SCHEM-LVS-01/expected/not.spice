** sch_path: /pdk/sky130A/libs.tech/xschem/sky130_tests/not.sch
.subckt not y a VCCPIN VSSPIN
*.PININFO y:O a:I
XM1 DN a VSSPIN VSSPIN sky130_fd_pr__nfet_01v8 L=L_N W=W_N nf=1
XM2 DP a VCCPIN VCCPIN sky130_fd_pr__pfet_01v8 L=L_P W=W_P nf=1
Vmeas DP y 0
.save i(vmeas)
Vmeas1 y DN 0
.save i(vmeas1)
.save v(dp)
.save v(dn)
.ends

** sch_path: /work/input/inv_1.sch
.subckt inv_1 A Y VPWR VPB VGND VNB
*.PININFO A:I Y:O VPWR:B VPB:B VGND:B VNB:B
XM2 Y A VPWR VPB sky130_fd_pr__pfet_01v8_hvt L=0.15 W=1 nf=1
XM1 Y A VGND VNB sky130_fd_pr__nfet_01v8 L=0.15 W=0.65 nf=1
.ends

** sch_path: /pdk/sky130A/libs.tech/xschem/sky130_tests/gain_stage.sch
**.subckt gain_stage IN OUT VCC VSS START_N START EN_N
*.ipin IN
*.ipin VSS
*.ipin VCC
*.opin OUT
*.ipin START
*.ipin START_N
*.ipin EN_N
C5 OUT 0 4f
XM6 OUT IN net1 VSS sky130_fd_pr__ L=1 W=WN nf=1 ad='int((1 + 1)/2) * WN / 1 * 0.29' as='int((1 + 2)/2) * WN / 1 * 0.29' pd='2*int((1 + 1)/2) * (WN / 1 + 0.29)'
+ ps='2*int((1 + 2)/2) * (WN / 1 + 0.29)' nrd='0.29 / WN ' nrs='0.29 / WN ' sa=0 sb=0 sd=0 mult=1
v4 net1 VSS 0
.save i(v4)
XM7 OUT EN_N VSS VSS sky130_fd_pr__nfet_01v8 L=0.15 W=0.5 nf=1 ad=0.145 as=0.145 pd=1.58 ps=1.58 nrd=0.58 nrs=0.58 sa=0 sb=0 sd=0
+ mult=3 m=3
XM46 net6 EN_N VCC VCC sky130_fd_pr__pfet_01v8 L=0.15 W=5 nf=1 ad=1.45 as=1.45 pd=10.58 ps=10.58 nrd=0.058 nrs=0.058 sa=0 sb=0
+ sd=0 mult=1
v17 net6 net2 0
.save i(v17)
XM5 OUT IN net2 VCC sky130_fd_pr__pfet_01v8_lvt L=1 W=WP nf=1 ad='int((1 + 1)/2) * WP / 1 * 0.29' as='int((1 + 2)/2) * WP / 1 * 0.29'
+ pd='2*int((1 + 1)/2) * (WP / 1 + 0.29)' ps='2*int((1 + 2)/2) * (WP / 1 + 0.29)' nrd='0.29 / WP ' nrs='0.29 / WP ' sa=0 sb=0 sd=0 mult=1
XM8 net4 ADJ net3 VCC sky130_fd_pr__pfet_01v8_lvt L=1 W=WP nf=1 ad='int((1 + 1)/2) * WP / 1 * 0.29' as='int((1 + 2)/2) * WP / 1 * 0.29'
+ pd='2*int((1 + 1)/2) * (WP / 1 + 0.29)' ps='2*int((1 + 2)/2) * (WP / 1 + 0.29)' nrd='0.29 / WP ' nrs='0.29 / WP ' sa=0 sb=0 sd=0 mult=1
XM9 net4 ADJ net5 VSS sky130_fd_pr__ L=1 W=WN nf=1 ad='int((1 + 1)/2) * WN / 1 * 0.29' as='int((1 + 2)/2) * WN / 1 * 0.29' pd='2*int((1 + 1)/2) * (WN / 1 + 0.29)'
+ ps='2*int((1 + 2)/2) * (WN / 1 + 0.29)' nrd='0.29 / WN ' nrs='0.29 / WN ' sa=0 sb=0 sd=0 mult=1
XM10 net5 VCC VSS VSS sky130_fd_pr__nfet_01v8 L=4 W=WN nf=1 ad='int((1 + 1)/2) * WN / 1 * 0.29' as='int((1 + 2)/2) * WN / 1 * 0.29'
+ pd='2*int((1 + 1)/2) * (WN / 1 + 0.29)' ps='2*int((1 + 2)/2) * (WN / 1 + 0.29)' nrd='0.29 / WN ' nrs='0.29 / WN ' sa=0 sb=0 sd=0 mult=1
XM1 net3 EN_N VCC VCC sky130_fd_pr__pfet_01v8 L=4 W=WP nf=1 ad='int((1 + 1)/2) * WP / 1 * 0.29' as='int((1 + 2)/2) * WP / 1 * 0.29'
+ pd='2*int((1 + 1)/2) * (WP / 1 + 0.29)' ps='2*int((1 + 2)/2) * (WP / 1 + 0.29)' nrd='0.29 / WP ' nrs='0.29 / WP ' sa=0 sb=0 sd=0 mult=1
C1 IN 0 4f
x6 ADJ OUT START START_N VCC VSS passgate_1 W_N=0.42 L_N=0.35 W_P=0.6 L_P=0.35
XC2 ADJ VSS sky130_fd_pr__cap_mim_m3_2 W=wcap L=wcap MF=2 m=2
v1 net4 OUT 0
.save i(v1)
**.ends

* expanding   symbol:  sky130_tests/passgate.sym # of pins=4
** sym_path: /pdk/sky130A/libs.tech/xschem/sky130_tests/passgate.sym
** sch_path: /pdk/sky130A/libs.tech/xschem/sky130_tests/passgate.sch
.subckt passgate Z A GP GN VCCBPIN VSSBPIN  W_N=1 L_N=0.2 W_P=1 L_P=0.2

*.iopin A
*.iopin Z
*.ipin GP
*.ipin GN
XM1 Z GN A VSSBPIN sky130_fd_pr__nfet_01v8 L=L_N W=W_N nf=1 ad='int((1 + 1)/2) * W_N / 1 * 0.29' as='int((1 + 2)/2) * W_N / 1 * 0.29'
+ pd='2*int((1 + 1)/2) * (W_N / 1 + 0.29)' ps='2*int((1 + 2)/2) * (W_N / 1 + 0.29)' nrd='0.29 / W_N ' nrs='0.29 / W_N ' sa=0 sb=0 sd=0
+ mult=1
XM2 Z GP A VCCBPIN sky130_fd_pr__pfet_01v8 L=L_P W=W_P nf=1 ad='int((1 + 1)/2) * W_P / 1 * 0.29' as='int((1 + 2)/2) * W_P / 1 * 0.29'
+ pd='2*int((1 + 1)/2) * (W_P / 1 + 0.29)' ps='2*int((1 + 2)/2) * (W_P / 1 + 0.29)' nrd='0.29 / W_P ' nrs='0.29 / W_P ' sa=0 sb=0 sd=0
+ mult=1
* noconn VCCBPIN
* noconn VSSBPIN
.ends

* expanding   symbol:  passgate_1.sym # of pins=4
** sym_path: /pdk/sky130A/libs.tech/xschem/sky130_tests/passgate.sym
** sch_path: /pdk/sky130A/libs.tech/xschem/sky130_tests/passgate.sch
.subckt passgate_1 Z A GP GN VCCBPIN VSSBPIN  W_N=1 L_N=0.2 W_P=1 L_P=0.2

*.iopin A
*.iopin Z
*.ipin GP
*.ipin GN
XM1 Z GN A VSSBPIN sky130_fd_pr__nfet_01v8 L=L_N W=W_N nf=1 ad='int((1 + 1)/2) * W_N / 1 * 0.29' as='int((1 + 2)/2) * W_N / 1 * 0.29'
+ pd='2*int((1 + 1)/2) * (W_N / 1 + 0.29)' ps='2*int((1 + 2)/2) * (W_N / 1 + 0.29)' nrd='0.29 / W_N ' nrs='0.29 / W_N ' sa=0 sb=0 sd=0
+ mult=1
XM2 Z GP A VCCBPIN sky130_fd_pr__pfet_01v8_lvt L=L_P W=W_P nf=1 ad='int((1 + 1)/2) * W_P / 1 * 0.29' as='int((1 + 2)/2) * W_P / 1 * 0.29'
+ pd='2*int((1 + 1)/2) * (W_P / 1 + 0.29)' ps='2*int((1 + 2)/2) * (W_P / 1 + 0.29)' nrd='0.29 / W_P ' nrs='0.29 / W_P ' sa=0 sb=0 sd=0
+ mult=1
* noconn VCCBPIN
* noconn VSSBPIN
.ends

.end

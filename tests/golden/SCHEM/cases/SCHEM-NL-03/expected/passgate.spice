** sch_path: /pdk/sky130A/libs.tech/xschem/sky130_tests/passgate.sch
**.subckt passgate Z A GP GN VCCBPIN VSSBPIN
*.iopin A
*.iopin Z
*.ipin GP
*.ipin GN
XM1 Z GN A VSSBPIN sky130_fd_pr__ L=L_N W=W_N nf=1 ad='int((1 + 1)/2) * W_N / 1 * 0.29' as='int((1 + 2)/2) * W_N / 1 * 0.29' pd='2*int((1 + 1)/2) * (W_N / 1 + 0.29)'
+ ps='2*int((1 + 2)/2) * (W_N / 1 + 0.29)' nrd='0.29 / W_N ' nrs='0.29 / W_N ' sa=0 sb=0 sd=0 mult=1
XM2 Z GP A VCCBPIN sky130_fd_pr__ L=L_P W=W_P nf=1 ad='int((1 + 1)/2) * W_P / 1 * 0.29' as='int((1 + 2)/2) * W_P / 1 * 0.29' pd='2*int((1 + 1)/2) * (W_P / 1 + 0.29)'
+ ps='2*int((1 + 2)/2) * (W_P / 1 + 0.29)' nrd='0.29 / W_P ' nrs='0.29 / W_P ' sa=0 sb=0 sd=0 mult=1
* noconn VCCBPIN
* noconn VSSBPIN
**.ends
.end

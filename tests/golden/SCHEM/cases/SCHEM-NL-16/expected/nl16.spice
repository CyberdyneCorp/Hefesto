** sch_path: /work/input/nl16.sch
**.subckt nl16
x1 A B inv
x2 A B inv
**.ends

* expanding   symbol:  libA/inv.sym # of pins=2
** sym_path: /work/input/libA/inv.sym
** sch_path: /work/input/libA/inv.sch
.subckt inv A Y
*.iopin A
*.iopin Y
R1 A Y 1k
.ends

.end

** sch_path: /pdk/sky130A/libs.tech/xschem/sky130_tests/test_inv.sch
**.subckt test_inv
C1 Z[1] 0 4f
C2 Z[2] 0 4f
C3 Z[3] 0 4f
C4 Z[4] 0 4f
C5 Z[5] 0 4f
C6 Z[6] 0 4f
C7 Z[0] 0 4.01f
C8 Y[1] 0 4f
C9 Y[2] 0 4f
C10 Y[3] 0 4f
C11 Y[4] 0 4f
C12 Y[5] 0 4f
C13 Y[6] 0 4f
C14 Y[0] 0 4.01f
x4 Z[1] Z[0] VCC VSS not W_N=WN L_N=0.15 W_P=WP L_P=0.15
x1 Z[2] Z[1] VCC VSS not W_N=WN L_N=0.15 W_P=WP L_P=0.15
x2 Z[3] Z[2] VCC VSS not W_N=WN L_N=0.15 W_P=WP L_P=0.15
x3 Z[4] Z[3] VCC VSS not W_N=WN L_N=0.15 W_P=WP L_P=0.15
x5 Z[5] Z[4] VCC VSS not W_N=WN L_N=0.15 W_P=WP L_P=0.15
x6 Z[6] Z[5] VCC VSS not W_N=WN L_N=0.15 W_P=WP L_P=0.15
x7 Z[0] Z[6] VCC VSS not W_N=WN L_N=0.15 W_P=WP L_P=0.15
x8 Y[0] Y[1] VCC VSS lvtnot W_N=WN L_N=0.15 W_P=WP L_P=0.35
x9 Y[1] Y[2] VCC VSS lvtnot W_N=WN L_N=0.15 W_P=WP L_P=0.35
x10 Y[2] Y[3] VCC VSS lvtnot W_N=WN L_N=0.15 W_P=WP L_P=0.35
x11 Y[3] Y[4] VCC VSS lvtnot W_N=WN L_N=0.15 W_P=WP L_P=0.35
x12 Y[4] Y[5] VCC VSS lvtnot W_N=WN L_N=0.15 W_P=WP L_P=0.35
x13 Y[5] Y[6] VCC VSS lvtnot W_N=WN L_N=0.15 W_P=WP L_P=0.35
x14 Y[6] Y[0] VCC VSS lvtnot W_N=WN L_N=0.15 W_P=WP L_P=0.35
* tap: Z[6:0] --> Z[0]
* tap: Z[6:0] --> Z[1]
* tap: Z[6:0] --> Z[2]
* tap: Z[6:0] --> Z[3]
* tap: Z[6:0] --> Z[4]
* tap: Z[6:0] --> Z[5]
* tap: Z[6:0] --> Z[6]
* tap: Y[6:0] --> Y[0]
* tap: Y[6:0] --> Y[1]
* tap: Y[6:0] --> Y[2]
* tap: Y[6:0] --> Y[3]
* tap: Y[6:0] --> Y[4]
* tap: Y[6:0] --> Y[5]
* tap: Y[6:0] --> Y[6]
**** begin user architecture code

.param VCC=1.8 WN=1 WP=2
vvss vss 0 dc 0
vvcc vcc 0
+ pwl 0 0 10n 0 10.1n 'VCC' 20n 'VCC' 20.1n 0
* .measure tran trise
* + TRIG v(z[6]) TD=10.5n VAL=0.1 RISE=1
* + TARG v(z[6]) TD=10.5n VAL=1.7 RISE=1
**** interactive sim
.control
  save all
  tran 0.004n 30n
  write test_inv.raw
  set appendwrite
  alterparam VCC=1.6
  reset
  save all
  tran 0.02n 30n
  write test_inv.raw
  quit 0
.endc

** opencircuitdesign pdks install
.lib /pdk/sky130A/libs.tech/combined/sky130.lib.spice tt

**** end user architecture code
**.ends

* expanding   symbol:  sky130_tests/not.sym # of pins=2
** sym_path: /pdk/sky130A/libs.tech/xschem/sky130_tests/not.sym
** sch_path: /pdk/sky130A/libs.tech/xschem/sky130_tests/not.sch
.subckt not y a VCCPIN VSSPIN     W_N=1 L_N=0.15 W_P=2 L_P=0.15
*.opin y
*.ipin a
XM1 DN a VSSPIN VSSPIN sky130_fd_pr__nfet_01v8 L=L_N W=W_N nf=1 ad='int((1 + 1)/2) * W_N / 1 * 0.29' as='int((1 + 2)/2) * W_N / 1 * 0.29'
+ pd='2*int((1 + 1)/2) * (W_N / 1 + 0.29)' ps='2*int((1 + 2)/2) * (W_N / 1 + 0.29)' nrd='0.29 / W_N ' nrs='0.29 / W_N ' sa=0 sb=0 sd=0
+ mult=1
XM2 DP a VCCPIN VCCPIN sky130_fd_pr__pfet_01v8 L=L_P W=W_P nf=1 ad='int((1 + 1)/2) * W_P / 1 * 0.29' as='int((1 + 2)/2) * W_P / 1 * 0.29'
+ pd='2*int((1 + 1)/2) * (W_P / 1 + 0.29)' ps='2*int((1 + 2)/2) * (W_P / 1 + 0.29)' nrd='0.29 / W_P ' nrs='0.29 / W_P ' sa=0 sb=0 sd=0
+ mult=1
Vmeas DP y 0
.save i(vmeas)
Vmeas1 y DN 0
.save i(vmeas1)
.save v(dp)
.save v(dn)
.ends

* expanding   symbol:  sky130_tests/lvtnot.sym # of pins=2
** sym_path: /pdk/sky130A/libs.tech/xschem/sky130_tests/lvtnot.sym
** sch_path: /pdk/sky130A/libs.tech/xschem/sky130_tests/lvtnot.sch
.subckt lvtnot a y VCCPIN VSSPIN     W_N=1 L_N=0.15 W_P=2 L_P=0.35
*.opin y
*.ipin a
XM2 y a VCCPIN VCCPIN sky130_fd_pr__pfet_01v8_lvt L=L_P W=W_P nf=1 ad='int((1 + 1)/2) * W_P / 1 * 0.29' as='int((1 + 2)/2) * W_P / 1 * 0.29'
+ pd='2*int((1 + 1)/2) * (W_P / 1 + 0.29)' ps='2*int((1 + 2)/2) * (W_P / 1 + 0.29)' nrd='0.29 / W_P ' nrs='0.29 / W_P ' sa=0 sb=0 sd=0
+ mult=1
XM1 y a VSSPIN VSSPIN sky130_fd_pr__nfet_01v8_lvt L=L_N W=W_N nf=1 ad='int((1 + 1)/2) * W_N / 1 * 0.29' as='int((1 + 2)/2) * W_N / 1 * 0.29'
+ pd='2*int((1 + 1)/2) * (W_N / 1 + 0.29)' ps='2*int((1 + 2)/2) * (W_N / 1 + 0.29)' nrd='0.29 / W_N ' nrs='0.29 / W_N ' sa=0 sb=0 sd=0
+ mult=1
.ends

.end

** sch_path: /work/input/SC_Test.sch
**.subckt SC_Test
V1 VIN 0 5
R1 VIN VOUT 1k
C1 VOUT 0 1n
**** begin user architecture code

.param
.tran 1n 1u
.save all

**** end user architecture code
**.ends
.end

** sch_path: /work/input/ihp_style_tb.sch
**.subckt ihp_style_tb
Vin IN GND 1.2
Vmeas IN net1 0
.save i(vmeas)
R1 net1 GND 10k
C1 IN GND 1p
**** begin user architecture code

.param rload=20k

.control
op
.endc

**** end user architecture code
**.ends
.GLOBAL GND
.end

.subckt ram a b w=1
R1 a b 1k
.subckt inner x
.ends
.ends
R9 a b 1k

.include self.sp
.include ~/x.sp
.include ~ann/x.sp
.include "missing.sp"
R1 a b 1k

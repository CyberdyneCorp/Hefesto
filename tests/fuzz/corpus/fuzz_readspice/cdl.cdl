.SUBCKT inv A Y VDD VSS
*.PININFO A:I Y:O VDD:B VSS:B
.ENDS
